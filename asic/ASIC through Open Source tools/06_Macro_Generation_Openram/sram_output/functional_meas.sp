.meas tran vdout0_0ck40 FIND v(dout0_0) AT=50.05n

.meas tran vdout0_1ck40 FIND v(dout0_1) AT=50.05n

.meas tran vdout0_2ck40 FIND v(dout0_2) AT=50.05n

.meas tran vdout0_3ck40 FIND v(dout0_3) AT=50.05n

.meas tran vdout0_4ck40 FIND v(dout0_4) AT=50.05n

.meas tran vdout0_5ck40 FIND v(dout0_5) AT=50.05n

.meas tran vdout0_6ck40 FIND v(dout0_6) AT=50.05n

.meas tran vdout0_7ck40 FIND v(dout0_7) AT=50.05n

.meas tran vdout0_8ck40 FIND v(dout0_8) AT=50.05n

.meas tran vdout0_9ck40 FIND v(dout0_9) AT=50.05n

.meas tran vdout0_10ck40 FIND v(dout0_10) AT=50.05n

.meas tran vdout0_11ck40 FIND v(dout0_11) AT=50.05n

.meas tran vdout0_12ck40 FIND v(dout0_12) AT=50.05n

.meas tran vdout0_13ck40 FIND v(dout0_13) AT=50.05n

.meas tran vdout0_14ck40 FIND v(dout0_14) AT=50.05n

.meas tran vdout0_15ck40 FIND v(dout0_15) AT=50.05n

.meas tran vdout0_16ck40 FIND v(dout0_16) AT=50.05n

.meas tran vdout0_17ck40 FIND v(dout0_17) AT=50.05n

.meas tran vdout0_18ck40 FIND v(dout0_18) AT=50.05n

.meas tran vdout0_19ck40 FIND v(dout0_19) AT=50.05n

.meas tran vdout0_20ck40 FIND v(dout0_20) AT=50.05n

.meas tran vdout0_21ck40 FIND v(dout0_21) AT=50.05n

.meas tran vdout0_22ck40 FIND v(dout0_22) AT=50.05n

.meas tran vdout0_23ck40 FIND v(dout0_23) AT=50.05n

.meas tran vdout0_24ck40 FIND v(dout0_24) AT=50.05n

.meas tran vdout0_25ck40 FIND v(dout0_25) AT=50.05n

.meas tran vdout0_26ck40 FIND v(dout0_26) AT=50.05n

.meas tran vdout0_27ck40 FIND v(dout0_27) AT=50.05n

.meas tran vdout0_28ck40 FIND v(dout0_28) AT=50.05n

.meas tran vdout0_29ck40 FIND v(dout0_29) AT=50.05n

.meas tran vdout0_30ck40 FIND v(dout0_30) AT=50.05n

.meas tran vdout0_31ck40 FIND v(dout0_31) AT=50.05n

.meas tran vdout0_0ck100 FIND v(dout0_0) AT=110.05n

.meas tran vdout0_1ck100 FIND v(dout0_1) AT=110.05n

.meas tran vdout0_2ck100 FIND v(dout0_2) AT=110.05n

.meas tran vdout0_3ck100 FIND v(dout0_3) AT=110.05n

.meas tran vdout0_4ck100 FIND v(dout0_4) AT=110.05n

.meas tran vdout0_5ck100 FIND v(dout0_5) AT=110.05n

.meas tran vdout0_6ck100 FIND v(dout0_6) AT=110.05n

.meas tran vdout0_7ck100 FIND v(dout0_7) AT=110.05n

.meas tran vdout0_8ck100 FIND v(dout0_8) AT=110.05n

.meas tran vdout0_9ck100 FIND v(dout0_9) AT=110.05n

.meas tran vdout0_10ck100 FIND v(dout0_10) AT=110.05n

.meas tran vdout0_11ck100 FIND v(dout0_11) AT=110.05n

.meas tran vdout0_12ck100 FIND v(dout0_12) AT=110.05n

.meas tran vdout0_13ck100 FIND v(dout0_13) AT=110.05n

.meas tran vdout0_14ck100 FIND v(dout0_14) AT=110.05n

.meas tran vdout0_15ck100 FIND v(dout0_15) AT=110.05n

.meas tran vdout0_16ck100 FIND v(dout0_16) AT=110.05n

.meas tran vdout0_17ck100 FIND v(dout0_17) AT=110.05n

.meas tran vdout0_18ck100 FIND v(dout0_18) AT=110.05n

.meas tran vdout0_19ck100 FIND v(dout0_19) AT=110.05n

.meas tran vdout0_20ck100 FIND v(dout0_20) AT=110.05n

.meas tran vdout0_21ck100 FIND v(dout0_21) AT=110.05n

.meas tran vdout0_22ck100 FIND v(dout0_22) AT=110.05n

.meas tran vdout0_23ck100 FIND v(dout0_23) AT=110.05n

.meas tran vdout0_24ck100 FIND v(dout0_24) AT=110.05n

.meas tran vdout0_25ck100 FIND v(dout0_25) AT=110.05n

.meas tran vdout0_26ck100 FIND v(dout0_26) AT=110.05n

.meas tran vdout0_27ck100 FIND v(dout0_27) AT=110.05n

.meas tran vdout0_28ck100 FIND v(dout0_28) AT=110.05n

.meas tran vdout0_29ck100 FIND v(dout0_29) AT=110.05n

.meas tran vdout0_30ck100 FIND v(dout0_30) AT=110.05n

.meas tran vdout0_31ck100 FIND v(dout0_31) AT=110.05n

.meas tran vdout0_0ck120 FIND v(dout0_0) AT=130.05n

.meas tran vdout0_1ck120 FIND v(dout0_1) AT=130.05n

.meas tran vdout0_2ck120 FIND v(dout0_2) AT=130.05n

.meas tran vdout0_3ck120 FIND v(dout0_3) AT=130.05n

.meas tran vdout0_4ck120 FIND v(dout0_4) AT=130.05n

.meas tran vdout0_5ck120 FIND v(dout0_5) AT=130.05n

.meas tran vdout0_6ck120 FIND v(dout0_6) AT=130.05n

.meas tran vdout0_7ck120 FIND v(dout0_7) AT=130.05n

.meas tran vdout0_8ck120 FIND v(dout0_8) AT=130.05n

.meas tran vdout0_9ck120 FIND v(dout0_9) AT=130.05n

.meas tran vdout0_10ck120 FIND v(dout0_10) AT=130.05n

.meas tran vdout0_11ck120 FIND v(dout0_11) AT=130.05n

.meas tran vdout0_12ck120 FIND v(dout0_12) AT=130.05n

.meas tran vdout0_13ck120 FIND v(dout0_13) AT=130.05n

.meas tran vdout0_14ck120 FIND v(dout0_14) AT=130.05n

.meas tran vdout0_15ck120 FIND v(dout0_15) AT=130.05n

.meas tran vdout0_16ck120 FIND v(dout0_16) AT=130.05n

.meas tran vdout0_17ck120 FIND v(dout0_17) AT=130.05n

.meas tran vdout0_18ck120 FIND v(dout0_18) AT=130.05n

.meas tran vdout0_19ck120 FIND v(dout0_19) AT=130.05n

.meas tran vdout0_20ck120 FIND v(dout0_20) AT=130.05n

.meas tran vdout0_21ck120 FIND v(dout0_21) AT=130.05n

.meas tran vdout0_22ck120 FIND v(dout0_22) AT=130.05n

.meas tran vdout0_23ck120 FIND v(dout0_23) AT=130.05n

.meas tran vdout0_24ck120 FIND v(dout0_24) AT=130.05n

.meas tran vdout0_25ck120 FIND v(dout0_25) AT=130.05n

.meas tran vdout0_26ck120 FIND v(dout0_26) AT=130.05n

.meas tran vdout0_27ck120 FIND v(dout0_27) AT=130.05n

.meas tran vdout0_28ck120 FIND v(dout0_28) AT=130.05n

.meas tran vdout0_29ck120 FIND v(dout0_29) AT=130.05n

.meas tran vdout0_30ck120 FIND v(dout0_30) AT=130.05n

.meas tran vdout0_31ck120 FIND v(dout0_31) AT=130.05n

.meas tran vdout0_0ck180 FIND v(dout0_0) AT=190.05n

.meas tran vdout0_1ck180 FIND v(dout0_1) AT=190.05n

.meas tran vdout0_2ck180 FIND v(dout0_2) AT=190.05n

.meas tran vdout0_3ck180 FIND v(dout0_3) AT=190.05n

.meas tran vdout0_4ck180 FIND v(dout0_4) AT=190.05n

.meas tran vdout0_5ck180 FIND v(dout0_5) AT=190.05n

.meas tran vdout0_6ck180 FIND v(dout0_6) AT=190.05n

.meas tran vdout0_7ck180 FIND v(dout0_7) AT=190.05n

.meas tran vdout0_8ck180 FIND v(dout0_8) AT=190.05n

.meas tran vdout0_9ck180 FIND v(dout0_9) AT=190.05n

.meas tran vdout0_10ck180 FIND v(dout0_10) AT=190.05n

.meas tran vdout0_11ck180 FIND v(dout0_11) AT=190.05n

.meas tran vdout0_12ck180 FIND v(dout0_12) AT=190.05n

.meas tran vdout0_13ck180 FIND v(dout0_13) AT=190.05n

.meas tran vdout0_14ck180 FIND v(dout0_14) AT=190.05n

.meas tran vdout0_15ck180 FIND v(dout0_15) AT=190.05n

.meas tran vdout0_16ck180 FIND v(dout0_16) AT=190.05n

.meas tran vdout0_17ck180 FIND v(dout0_17) AT=190.05n

.meas tran vdout0_18ck180 FIND v(dout0_18) AT=190.05n

.meas tran vdout0_19ck180 FIND v(dout0_19) AT=190.05n

.meas tran vdout0_20ck180 FIND v(dout0_20) AT=190.05n

.meas tran vdout0_21ck180 FIND v(dout0_21) AT=190.05n

.meas tran vdout0_22ck180 FIND v(dout0_22) AT=190.05n

.meas tran vdout0_23ck180 FIND v(dout0_23) AT=190.05n

.meas tran vdout0_24ck180 FIND v(dout0_24) AT=190.05n

.meas tran vdout0_25ck180 FIND v(dout0_25) AT=190.05n

.meas tran vdout0_26ck180 FIND v(dout0_26) AT=190.05n

.meas tran vdout0_27ck180 FIND v(dout0_27) AT=190.05n

.meas tran vdout0_28ck180 FIND v(dout0_28) AT=190.05n

.meas tran vdout0_29ck180 FIND v(dout0_29) AT=190.05n

.meas tran vdout0_30ck180 FIND v(dout0_30) AT=190.05n

.meas tran vdout0_31ck180 FIND v(dout0_31) AT=190.05n

.meas tran vdout0_0ck210 FIND v(dout0_0) AT=220.05n

.meas tran vdout0_1ck210 FIND v(dout0_1) AT=220.05n

.meas tran vdout0_2ck210 FIND v(dout0_2) AT=220.05n

.meas tran vdout0_3ck210 FIND v(dout0_3) AT=220.05n

.meas tran vdout0_4ck210 FIND v(dout0_4) AT=220.05n

.meas tran vdout0_5ck210 FIND v(dout0_5) AT=220.05n

.meas tran vdout0_6ck210 FIND v(dout0_6) AT=220.05n

.meas tran vdout0_7ck210 FIND v(dout0_7) AT=220.05n

.meas tran vdout0_8ck210 FIND v(dout0_8) AT=220.05n

.meas tran vdout0_9ck210 FIND v(dout0_9) AT=220.05n

.meas tran vdout0_10ck210 FIND v(dout0_10) AT=220.05n

.meas tran vdout0_11ck210 FIND v(dout0_11) AT=220.05n

.meas tran vdout0_12ck210 FIND v(dout0_12) AT=220.05n

.meas tran vdout0_13ck210 FIND v(dout0_13) AT=220.05n

.meas tran vdout0_14ck210 FIND v(dout0_14) AT=220.05n

.meas tran vdout0_15ck210 FIND v(dout0_15) AT=220.05n

.meas tran vdout0_16ck210 FIND v(dout0_16) AT=220.05n

.meas tran vdout0_17ck210 FIND v(dout0_17) AT=220.05n

.meas tran vdout0_18ck210 FIND v(dout0_18) AT=220.05n

.meas tran vdout0_19ck210 FIND v(dout0_19) AT=220.05n

.meas tran vdout0_20ck210 FIND v(dout0_20) AT=220.05n

.meas tran vdout0_21ck210 FIND v(dout0_21) AT=220.05n

.meas tran vdout0_22ck210 FIND v(dout0_22) AT=220.05n

.meas tran vdout0_23ck210 FIND v(dout0_23) AT=220.05n

.meas tran vdout0_24ck210 FIND v(dout0_24) AT=220.05n

.meas tran vdout0_25ck210 FIND v(dout0_25) AT=220.05n

.meas tran vdout0_26ck210 FIND v(dout0_26) AT=220.05n

.meas tran vdout0_27ck210 FIND v(dout0_27) AT=220.05n

.meas tran vdout0_28ck210 FIND v(dout0_28) AT=220.05n

.meas tran vdout0_29ck210 FIND v(dout0_29) AT=220.05n

.meas tran vdout0_30ck210 FIND v(dout0_30) AT=220.05n

.meas tran vdout0_31ck210 FIND v(dout0_31) AT=220.05n

.meas tran vdout0_0ck240 FIND v(dout0_0) AT=250.05n

.meas tran vdout0_1ck240 FIND v(dout0_1) AT=250.05n

.meas tran vdout0_2ck240 FIND v(dout0_2) AT=250.05n

.meas tran vdout0_3ck240 FIND v(dout0_3) AT=250.05n

.meas tran vdout0_4ck240 FIND v(dout0_4) AT=250.05n

.meas tran vdout0_5ck240 FIND v(dout0_5) AT=250.05n

.meas tran vdout0_6ck240 FIND v(dout0_6) AT=250.05n

.meas tran vdout0_7ck240 FIND v(dout0_7) AT=250.05n

.meas tran vdout0_8ck240 FIND v(dout0_8) AT=250.05n

.meas tran vdout0_9ck240 FIND v(dout0_9) AT=250.05n

.meas tran vdout0_10ck240 FIND v(dout0_10) AT=250.05n

.meas tran vdout0_11ck240 FIND v(dout0_11) AT=250.05n

.meas tran vdout0_12ck240 FIND v(dout0_12) AT=250.05n

.meas tran vdout0_13ck240 FIND v(dout0_13) AT=250.05n

.meas tran vdout0_14ck240 FIND v(dout0_14) AT=250.05n

.meas tran vdout0_15ck240 FIND v(dout0_15) AT=250.05n

.meas tran vdout0_16ck240 FIND v(dout0_16) AT=250.05n

.meas tran vdout0_17ck240 FIND v(dout0_17) AT=250.05n

.meas tran vdout0_18ck240 FIND v(dout0_18) AT=250.05n

.meas tran vdout0_19ck240 FIND v(dout0_19) AT=250.05n

.meas tran vdout0_20ck240 FIND v(dout0_20) AT=250.05n

.meas tran vdout0_21ck240 FIND v(dout0_21) AT=250.05n

.meas tran vdout0_22ck240 FIND v(dout0_22) AT=250.05n

.meas tran vdout0_23ck240 FIND v(dout0_23) AT=250.05n

.meas tran vdout0_24ck240 FIND v(dout0_24) AT=250.05n

.meas tran vdout0_25ck240 FIND v(dout0_25) AT=250.05n

.meas tran vdout0_26ck240 FIND v(dout0_26) AT=250.05n

.meas tran vdout0_27ck240 FIND v(dout0_27) AT=250.05n

.meas tran vdout0_28ck240 FIND v(dout0_28) AT=250.05n

.meas tran vdout0_29ck240 FIND v(dout0_29) AT=250.05n

.meas tran vdout0_30ck240 FIND v(dout0_30) AT=250.05n

.meas tran vdout0_31ck240 FIND v(dout0_31) AT=250.05n

.meas tran vdout0_0ck260 FIND v(dout0_0) AT=270.05n

.meas tran vdout0_1ck260 FIND v(dout0_1) AT=270.05n

.meas tran vdout0_2ck260 FIND v(dout0_2) AT=270.05n

.meas tran vdout0_3ck260 FIND v(dout0_3) AT=270.05n

.meas tran vdout0_4ck260 FIND v(dout0_4) AT=270.05n

.meas tran vdout0_5ck260 FIND v(dout0_5) AT=270.05n

.meas tran vdout0_6ck260 FIND v(dout0_6) AT=270.05n

.meas tran vdout0_7ck260 FIND v(dout0_7) AT=270.05n

.meas tran vdout0_8ck260 FIND v(dout0_8) AT=270.05n

.meas tran vdout0_9ck260 FIND v(dout0_9) AT=270.05n

.meas tran vdout0_10ck260 FIND v(dout0_10) AT=270.05n

.meas tran vdout0_11ck260 FIND v(dout0_11) AT=270.05n

.meas tran vdout0_12ck260 FIND v(dout0_12) AT=270.05n

.meas tran vdout0_13ck260 FIND v(dout0_13) AT=270.05n

.meas tran vdout0_14ck260 FIND v(dout0_14) AT=270.05n

.meas tran vdout0_15ck260 FIND v(dout0_15) AT=270.05n

.meas tran vdout0_16ck260 FIND v(dout0_16) AT=270.05n

.meas tran vdout0_17ck260 FIND v(dout0_17) AT=270.05n

.meas tran vdout0_18ck260 FIND v(dout0_18) AT=270.05n

.meas tran vdout0_19ck260 FIND v(dout0_19) AT=270.05n

.meas tran vdout0_20ck260 FIND v(dout0_20) AT=270.05n

.meas tran vdout0_21ck260 FIND v(dout0_21) AT=270.05n

.meas tran vdout0_22ck260 FIND v(dout0_22) AT=270.05n

.meas tran vdout0_23ck260 FIND v(dout0_23) AT=270.05n

.meas tran vdout0_24ck260 FIND v(dout0_24) AT=270.05n

.meas tran vdout0_25ck260 FIND v(dout0_25) AT=270.05n

.meas tran vdout0_26ck260 FIND v(dout0_26) AT=270.05n

.meas tran vdout0_27ck260 FIND v(dout0_27) AT=270.05n

.meas tran vdout0_28ck260 FIND v(dout0_28) AT=270.05n

.meas tran vdout0_29ck260 FIND v(dout0_29) AT=270.05n

.meas tran vdout0_30ck260 FIND v(dout0_30) AT=270.05n

.meas tran vdout0_31ck260 FIND v(dout0_31) AT=270.05n

.meas tran vdout0_0ck270 FIND v(dout0_0) AT=280.05n

.meas tran vdout0_1ck270 FIND v(dout0_1) AT=280.05n

.meas tran vdout0_2ck270 FIND v(dout0_2) AT=280.05n

.meas tran vdout0_3ck270 FIND v(dout0_3) AT=280.05n

.meas tran vdout0_4ck270 FIND v(dout0_4) AT=280.05n

.meas tran vdout0_5ck270 FIND v(dout0_5) AT=280.05n

.meas tran vdout0_6ck270 FIND v(dout0_6) AT=280.05n

.meas tran vdout0_7ck270 FIND v(dout0_7) AT=280.05n

.meas tran vdout0_8ck270 FIND v(dout0_8) AT=280.05n

.meas tran vdout0_9ck270 FIND v(dout0_9) AT=280.05n

.meas tran vdout0_10ck270 FIND v(dout0_10) AT=280.05n

.meas tran vdout0_11ck270 FIND v(dout0_11) AT=280.05n

.meas tran vdout0_12ck270 FIND v(dout0_12) AT=280.05n

.meas tran vdout0_13ck270 FIND v(dout0_13) AT=280.05n

.meas tran vdout0_14ck270 FIND v(dout0_14) AT=280.05n

.meas tran vdout0_15ck270 FIND v(dout0_15) AT=280.05n

.meas tran vdout0_16ck270 FIND v(dout0_16) AT=280.05n

.meas tran vdout0_17ck270 FIND v(dout0_17) AT=280.05n

.meas tran vdout0_18ck270 FIND v(dout0_18) AT=280.05n

.meas tran vdout0_19ck270 FIND v(dout0_19) AT=280.05n

.meas tran vdout0_20ck270 FIND v(dout0_20) AT=280.05n

.meas tran vdout0_21ck270 FIND v(dout0_21) AT=280.05n

.meas tran vdout0_22ck270 FIND v(dout0_22) AT=280.05n

.meas tran vdout0_23ck270 FIND v(dout0_23) AT=280.05n

.meas tran vdout0_24ck270 FIND v(dout0_24) AT=280.05n

.meas tran vdout0_25ck270 FIND v(dout0_25) AT=280.05n

.meas tran vdout0_26ck270 FIND v(dout0_26) AT=280.05n

.meas tran vdout0_27ck270 FIND v(dout0_27) AT=280.05n

.meas tran vdout0_28ck270 FIND v(dout0_28) AT=280.05n

.meas tran vdout0_29ck270 FIND v(dout0_29) AT=280.05n

.meas tran vdout0_30ck270 FIND v(dout0_30) AT=280.05n

.meas tran vdout0_31ck270 FIND v(dout0_31) AT=280.05n

.meas tran vdout0_0ck290 FIND v(dout0_0) AT=300.05n

.meas tran vdout0_1ck290 FIND v(dout0_1) AT=300.05n

.meas tran vdout0_2ck290 FIND v(dout0_2) AT=300.05n

.meas tran vdout0_3ck290 FIND v(dout0_3) AT=300.05n

.meas tran vdout0_4ck290 FIND v(dout0_4) AT=300.05n

.meas tran vdout0_5ck290 FIND v(dout0_5) AT=300.05n

.meas tran vdout0_6ck290 FIND v(dout0_6) AT=300.05n

.meas tran vdout0_7ck290 FIND v(dout0_7) AT=300.05n

.meas tran vdout0_8ck290 FIND v(dout0_8) AT=300.05n

.meas tran vdout0_9ck290 FIND v(dout0_9) AT=300.05n

.meas tran vdout0_10ck290 FIND v(dout0_10) AT=300.05n

.meas tran vdout0_11ck290 FIND v(dout0_11) AT=300.05n

.meas tran vdout0_12ck290 FIND v(dout0_12) AT=300.05n

.meas tran vdout0_13ck290 FIND v(dout0_13) AT=300.05n

.meas tran vdout0_14ck290 FIND v(dout0_14) AT=300.05n

.meas tran vdout0_15ck290 FIND v(dout0_15) AT=300.05n

.meas tran vdout0_16ck290 FIND v(dout0_16) AT=300.05n

.meas tran vdout0_17ck290 FIND v(dout0_17) AT=300.05n

.meas tran vdout0_18ck290 FIND v(dout0_18) AT=300.05n

.meas tran vdout0_19ck290 FIND v(dout0_19) AT=300.05n

.meas tran vdout0_20ck290 FIND v(dout0_20) AT=300.05n

.meas tran vdout0_21ck290 FIND v(dout0_21) AT=300.05n

.meas tran vdout0_22ck290 FIND v(dout0_22) AT=300.05n

.meas tran vdout0_23ck290 FIND v(dout0_23) AT=300.05n

.meas tran vdout0_24ck290 FIND v(dout0_24) AT=300.05n

.meas tran vdout0_25ck290 FIND v(dout0_25) AT=300.05n

.meas tran vdout0_26ck290 FIND v(dout0_26) AT=300.05n

.meas tran vdout0_27ck290 FIND v(dout0_27) AT=300.05n

.meas tran vdout0_28ck290 FIND v(dout0_28) AT=300.05n

.meas tran vdout0_29ck290 FIND v(dout0_29) AT=300.05n

.meas tran vdout0_30ck290 FIND v(dout0_30) AT=300.05n

.meas tran vdout0_31ck290 FIND v(dout0_31) AT=300.05n

.meas tran vdout0_0ck320 FIND v(dout0_0) AT=330.05n

.meas tran vdout0_1ck320 FIND v(dout0_1) AT=330.05n

.meas tran vdout0_2ck320 FIND v(dout0_2) AT=330.05n

.meas tran vdout0_3ck320 FIND v(dout0_3) AT=330.05n

.meas tran vdout0_4ck320 FIND v(dout0_4) AT=330.05n

.meas tran vdout0_5ck320 FIND v(dout0_5) AT=330.05n

.meas tran vdout0_6ck320 FIND v(dout0_6) AT=330.05n

.meas tran vdout0_7ck320 FIND v(dout0_7) AT=330.05n

.meas tran vdout0_8ck320 FIND v(dout0_8) AT=330.05n

.meas tran vdout0_9ck320 FIND v(dout0_9) AT=330.05n

.meas tran vdout0_10ck320 FIND v(dout0_10) AT=330.05n

.meas tran vdout0_11ck320 FIND v(dout0_11) AT=330.05n

.meas tran vdout0_12ck320 FIND v(dout0_12) AT=330.05n

.meas tran vdout0_13ck320 FIND v(dout0_13) AT=330.05n

.meas tran vdout0_14ck320 FIND v(dout0_14) AT=330.05n

.meas tran vdout0_15ck320 FIND v(dout0_15) AT=330.05n

.meas tran vdout0_16ck320 FIND v(dout0_16) AT=330.05n

.meas tran vdout0_17ck320 FIND v(dout0_17) AT=330.05n

.meas tran vdout0_18ck320 FIND v(dout0_18) AT=330.05n

.meas tran vdout0_19ck320 FIND v(dout0_19) AT=330.05n

.meas tran vdout0_20ck320 FIND v(dout0_20) AT=330.05n

.meas tran vdout0_21ck320 FIND v(dout0_21) AT=330.05n

.meas tran vdout0_22ck320 FIND v(dout0_22) AT=330.05n

.meas tran vdout0_23ck320 FIND v(dout0_23) AT=330.05n

.meas tran vdout0_24ck320 FIND v(dout0_24) AT=330.05n

.meas tran vdout0_25ck320 FIND v(dout0_25) AT=330.05n

.meas tran vdout0_26ck320 FIND v(dout0_26) AT=330.05n

.meas tran vdout0_27ck320 FIND v(dout0_27) AT=330.05n

.meas tran vdout0_28ck320 FIND v(dout0_28) AT=330.05n

.meas tran vdout0_29ck320 FIND v(dout0_29) AT=330.05n

.meas tran vdout0_30ck320 FIND v(dout0_30) AT=330.05n

.meas tran vdout0_31ck320 FIND v(dout0_31) AT=330.05n

.meas tran vdout0_0ck360 FIND v(dout0_0) AT=370.05n

.meas tran vdout0_1ck360 FIND v(dout0_1) AT=370.05n

.meas tran vdout0_2ck360 FIND v(dout0_2) AT=370.05n

.meas tran vdout0_3ck360 FIND v(dout0_3) AT=370.05n

.meas tran vdout0_4ck360 FIND v(dout0_4) AT=370.05n

.meas tran vdout0_5ck360 FIND v(dout0_5) AT=370.05n

.meas tran vdout0_6ck360 FIND v(dout0_6) AT=370.05n

.meas tran vdout0_7ck360 FIND v(dout0_7) AT=370.05n

.meas tran vdout0_8ck360 FIND v(dout0_8) AT=370.05n

.meas tran vdout0_9ck360 FIND v(dout0_9) AT=370.05n

.meas tran vdout0_10ck360 FIND v(dout0_10) AT=370.05n

.meas tran vdout0_11ck360 FIND v(dout0_11) AT=370.05n

.meas tran vdout0_12ck360 FIND v(dout0_12) AT=370.05n

.meas tran vdout0_13ck360 FIND v(dout0_13) AT=370.05n

.meas tran vdout0_14ck360 FIND v(dout0_14) AT=370.05n

.meas tran vdout0_15ck360 FIND v(dout0_15) AT=370.05n

.meas tran vdout0_16ck360 FIND v(dout0_16) AT=370.05n

.meas tran vdout0_17ck360 FIND v(dout0_17) AT=370.05n

.meas tran vdout0_18ck360 FIND v(dout0_18) AT=370.05n

.meas tran vdout0_19ck360 FIND v(dout0_19) AT=370.05n

.meas tran vdout0_20ck360 FIND v(dout0_20) AT=370.05n

.meas tran vdout0_21ck360 FIND v(dout0_21) AT=370.05n

.meas tran vdout0_22ck360 FIND v(dout0_22) AT=370.05n

.meas tran vdout0_23ck360 FIND v(dout0_23) AT=370.05n

.meas tran vdout0_24ck360 FIND v(dout0_24) AT=370.05n

.meas tran vdout0_25ck360 FIND v(dout0_25) AT=370.05n

.meas tran vdout0_26ck360 FIND v(dout0_26) AT=370.05n

.meas tran vdout0_27ck360 FIND v(dout0_27) AT=370.05n

.meas tran vdout0_28ck360 FIND v(dout0_28) AT=370.05n

.meas tran vdout0_29ck360 FIND v(dout0_29) AT=370.05n

.meas tran vdout0_30ck360 FIND v(dout0_30) AT=370.05n

.meas tran vdout0_31ck360 FIND v(dout0_31) AT=370.05n

.meas tran vdout0_0ck370 FIND v(dout0_0) AT=380.05n

.meas tran vdout0_1ck370 FIND v(dout0_1) AT=380.05n

.meas tran vdout0_2ck370 FIND v(dout0_2) AT=380.05n

.meas tran vdout0_3ck370 FIND v(dout0_3) AT=380.05n

.meas tran vdout0_4ck370 FIND v(dout0_4) AT=380.05n

.meas tran vdout0_5ck370 FIND v(dout0_5) AT=380.05n

.meas tran vdout0_6ck370 FIND v(dout0_6) AT=380.05n

.meas tran vdout0_7ck370 FIND v(dout0_7) AT=380.05n

.meas tran vdout0_8ck370 FIND v(dout0_8) AT=380.05n

.meas tran vdout0_9ck370 FIND v(dout0_9) AT=380.05n

.meas tran vdout0_10ck370 FIND v(dout0_10) AT=380.05n

.meas tran vdout0_11ck370 FIND v(dout0_11) AT=380.05n

.meas tran vdout0_12ck370 FIND v(dout0_12) AT=380.05n

.meas tran vdout0_13ck370 FIND v(dout0_13) AT=380.05n

.meas tran vdout0_14ck370 FIND v(dout0_14) AT=380.05n

.meas tran vdout0_15ck370 FIND v(dout0_15) AT=380.05n

.meas tran vdout0_16ck370 FIND v(dout0_16) AT=380.05n

.meas tran vdout0_17ck370 FIND v(dout0_17) AT=380.05n

.meas tran vdout0_18ck370 FIND v(dout0_18) AT=380.05n

.meas tran vdout0_19ck370 FIND v(dout0_19) AT=380.05n

.meas tran vdout0_20ck370 FIND v(dout0_20) AT=380.05n

.meas tran vdout0_21ck370 FIND v(dout0_21) AT=380.05n

.meas tran vdout0_22ck370 FIND v(dout0_22) AT=380.05n

.meas tran vdout0_23ck370 FIND v(dout0_23) AT=380.05n

.meas tran vdout0_24ck370 FIND v(dout0_24) AT=380.05n

.meas tran vdout0_25ck370 FIND v(dout0_25) AT=380.05n

.meas tran vdout0_26ck370 FIND v(dout0_26) AT=380.05n

.meas tran vdout0_27ck370 FIND v(dout0_27) AT=380.05n

.meas tran vdout0_28ck370 FIND v(dout0_28) AT=380.05n

.meas tran vdout0_29ck370 FIND v(dout0_29) AT=380.05n

.meas tran vdout0_30ck370 FIND v(dout0_30) AT=380.05n

.meas tran vdout0_31ck370 FIND v(dout0_31) AT=380.05n

.meas tran vdout0_0ck380 FIND v(dout0_0) AT=390.05n

.meas tran vdout0_1ck380 FIND v(dout0_1) AT=390.05n

.meas tran vdout0_2ck380 FIND v(dout0_2) AT=390.05n

.meas tran vdout0_3ck380 FIND v(dout0_3) AT=390.05n

.meas tran vdout0_4ck380 FIND v(dout0_4) AT=390.05n

.meas tran vdout0_5ck380 FIND v(dout0_5) AT=390.05n

.meas tran vdout0_6ck380 FIND v(dout0_6) AT=390.05n

.meas tran vdout0_7ck380 FIND v(dout0_7) AT=390.05n

.meas tran vdout0_8ck380 FIND v(dout0_8) AT=390.05n

.meas tran vdout0_9ck380 FIND v(dout0_9) AT=390.05n

.meas tran vdout0_10ck380 FIND v(dout0_10) AT=390.05n

.meas tran vdout0_11ck380 FIND v(dout0_11) AT=390.05n

.meas tran vdout0_12ck380 FIND v(dout0_12) AT=390.05n

.meas tran vdout0_13ck380 FIND v(dout0_13) AT=390.05n

.meas tran vdout0_14ck380 FIND v(dout0_14) AT=390.05n

.meas tran vdout0_15ck380 FIND v(dout0_15) AT=390.05n

.meas tran vdout0_16ck380 FIND v(dout0_16) AT=390.05n

.meas tran vdout0_17ck380 FIND v(dout0_17) AT=390.05n

.meas tran vdout0_18ck380 FIND v(dout0_18) AT=390.05n

.meas tran vdout0_19ck380 FIND v(dout0_19) AT=390.05n

.meas tran vdout0_20ck380 FIND v(dout0_20) AT=390.05n

.meas tran vdout0_21ck380 FIND v(dout0_21) AT=390.05n

.meas tran vdout0_22ck380 FIND v(dout0_22) AT=390.05n

.meas tran vdout0_23ck380 FIND v(dout0_23) AT=390.05n

.meas tran vdout0_24ck380 FIND v(dout0_24) AT=390.05n

.meas tran vdout0_25ck380 FIND v(dout0_25) AT=390.05n

.meas tran vdout0_26ck380 FIND v(dout0_26) AT=390.05n

.meas tran vdout0_27ck380 FIND v(dout0_27) AT=390.05n

.meas tran vdout0_28ck380 FIND v(dout0_28) AT=390.05n

.meas tran vdout0_29ck380 FIND v(dout0_29) AT=390.05n

.meas tran vdout0_30ck380 FIND v(dout0_30) AT=390.05n

.meas tran vdout0_31ck380 FIND v(dout0_31) AT=390.05n

.meas tran vdout0_0ck440 FIND v(dout0_0) AT=450.05n

.meas tran vdout0_1ck440 FIND v(dout0_1) AT=450.05n

.meas tran vdout0_2ck440 FIND v(dout0_2) AT=450.05n

.meas tran vdout0_3ck440 FIND v(dout0_3) AT=450.05n

.meas tran vdout0_4ck440 FIND v(dout0_4) AT=450.05n

.meas tran vdout0_5ck440 FIND v(dout0_5) AT=450.05n

.meas tran vdout0_6ck440 FIND v(dout0_6) AT=450.05n

.meas tran vdout0_7ck440 FIND v(dout0_7) AT=450.05n

.meas tran vdout0_8ck440 FIND v(dout0_8) AT=450.05n

.meas tran vdout0_9ck440 FIND v(dout0_9) AT=450.05n

.meas tran vdout0_10ck440 FIND v(dout0_10) AT=450.05n

.meas tran vdout0_11ck440 FIND v(dout0_11) AT=450.05n

.meas tran vdout0_12ck440 FIND v(dout0_12) AT=450.05n

.meas tran vdout0_13ck440 FIND v(dout0_13) AT=450.05n

.meas tran vdout0_14ck440 FIND v(dout0_14) AT=450.05n

.meas tran vdout0_15ck440 FIND v(dout0_15) AT=450.05n

.meas tran vdout0_16ck440 FIND v(dout0_16) AT=450.05n

.meas tran vdout0_17ck440 FIND v(dout0_17) AT=450.05n

.meas tran vdout0_18ck440 FIND v(dout0_18) AT=450.05n

.meas tran vdout0_19ck440 FIND v(dout0_19) AT=450.05n

.meas tran vdout0_20ck440 FIND v(dout0_20) AT=450.05n

.meas tran vdout0_21ck440 FIND v(dout0_21) AT=450.05n

.meas tran vdout0_22ck440 FIND v(dout0_22) AT=450.05n

.meas tran vdout0_23ck440 FIND v(dout0_23) AT=450.05n

.meas tran vdout0_24ck440 FIND v(dout0_24) AT=450.05n

.meas tran vdout0_25ck440 FIND v(dout0_25) AT=450.05n

.meas tran vdout0_26ck440 FIND v(dout0_26) AT=450.05n

.meas tran vdout0_27ck440 FIND v(dout0_27) AT=450.05n

.meas tran vdout0_28ck440 FIND v(dout0_28) AT=450.05n

.meas tran vdout0_29ck440 FIND v(dout0_29) AT=450.05n

.meas tran vdout0_30ck440 FIND v(dout0_30) AT=450.05n

.meas tran vdout0_31ck440 FIND v(dout0_31) AT=450.05n

.meas tran vdout0_0ck520 FIND v(dout0_0) AT=530.05n

.meas tran vdout0_1ck520 FIND v(dout0_1) AT=530.05n

.meas tran vdout0_2ck520 FIND v(dout0_2) AT=530.05n

.meas tran vdout0_3ck520 FIND v(dout0_3) AT=530.05n

.meas tran vdout0_4ck520 FIND v(dout0_4) AT=530.05n

.meas tran vdout0_5ck520 FIND v(dout0_5) AT=530.05n

.meas tran vdout0_6ck520 FIND v(dout0_6) AT=530.05n

.meas tran vdout0_7ck520 FIND v(dout0_7) AT=530.05n

.meas tran vdout0_8ck520 FIND v(dout0_8) AT=530.05n

.meas tran vdout0_9ck520 FIND v(dout0_9) AT=530.05n

.meas tran vdout0_10ck520 FIND v(dout0_10) AT=530.05n

.meas tran vdout0_11ck520 FIND v(dout0_11) AT=530.05n

.meas tran vdout0_12ck520 FIND v(dout0_12) AT=530.05n

.meas tran vdout0_13ck520 FIND v(dout0_13) AT=530.05n

.meas tran vdout0_14ck520 FIND v(dout0_14) AT=530.05n

.meas tran vdout0_15ck520 FIND v(dout0_15) AT=530.05n

.meas tran vdout0_16ck520 FIND v(dout0_16) AT=530.05n

.meas tran vdout0_17ck520 FIND v(dout0_17) AT=530.05n

.meas tran vdout0_18ck520 FIND v(dout0_18) AT=530.05n

.meas tran vdout0_19ck520 FIND v(dout0_19) AT=530.05n

.meas tran vdout0_20ck520 FIND v(dout0_20) AT=530.05n

.meas tran vdout0_21ck520 FIND v(dout0_21) AT=530.05n

.meas tran vdout0_22ck520 FIND v(dout0_22) AT=530.05n

.meas tran vdout0_23ck520 FIND v(dout0_23) AT=530.05n

.meas tran vdout0_24ck520 FIND v(dout0_24) AT=530.05n

.meas tran vdout0_25ck520 FIND v(dout0_25) AT=530.05n

.meas tran vdout0_26ck520 FIND v(dout0_26) AT=530.05n

.meas tran vdout0_27ck520 FIND v(dout0_27) AT=530.05n

.meas tran vdout0_28ck520 FIND v(dout0_28) AT=530.05n

.meas tran vdout0_29ck520 FIND v(dout0_29) AT=530.05n

.meas tran vdout0_30ck520 FIND v(dout0_30) AT=530.05n

.meas tran vdout0_31ck520 FIND v(dout0_31) AT=530.05n

.meas tran vdout0_0ck560 FIND v(dout0_0) AT=570.05n

.meas tran vdout0_1ck560 FIND v(dout0_1) AT=570.05n

.meas tran vdout0_2ck560 FIND v(dout0_2) AT=570.05n

.meas tran vdout0_3ck560 FIND v(dout0_3) AT=570.05n

.meas tran vdout0_4ck560 FIND v(dout0_4) AT=570.05n

.meas tran vdout0_5ck560 FIND v(dout0_5) AT=570.05n

.meas tran vdout0_6ck560 FIND v(dout0_6) AT=570.05n

.meas tran vdout0_7ck560 FIND v(dout0_7) AT=570.05n

.meas tran vdout0_8ck560 FIND v(dout0_8) AT=570.05n

.meas tran vdout0_9ck560 FIND v(dout0_9) AT=570.05n

.meas tran vdout0_10ck560 FIND v(dout0_10) AT=570.05n

.meas tran vdout0_11ck560 FIND v(dout0_11) AT=570.05n

.meas tran vdout0_12ck560 FIND v(dout0_12) AT=570.05n

.meas tran vdout0_13ck560 FIND v(dout0_13) AT=570.05n

.meas tran vdout0_14ck560 FIND v(dout0_14) AT=570.05n

.meas tran vdout0_15ck560 FIND v(dout0_15) AT=570.05n

.meas tran vdout0_16ck560 FIND v(dout0_16) AT=570.05n

.meas tran vdout0_17ck560 FIND v(dout0_17) AT=570.05n

.meas tran vdout0_18ck560 FIND v(dout0_18) AT=570.05n

.meas tran vdout0_19ck560 FIND v(dout0_19) AT=570.05n

.meas tran vdout0_20ck560 FIND v(dout0_20) AT=570.05n

.meas tran vdout0_21ck560 FIND v(dout0_21) AT=570.05n

.meas tran vdout0_22ck560 FIND v(dout0_22) AT=570.05n

.meas tran vdout0_23ck560 FIND v(dout0_23) AT=570.05n

.meas tran vdout0_24ck560 FIND v(dout0_24) AT=570.05n

.meas tran vdout0_25ck560 FIND v(dout0_25) AT=570.05n

.meas tran vdout0_26ck560 FIND v(dout0_26) AT=570.05n

.meas tran vdout0_27ck560 FIND v(dout0_27) AT=570.05n

.meas tran vdout0_28ck560 FIND v(dout0_28) AT=570.05n

.meas tran vdout0_29ck560 FIND v(dout0_29) AT=570.05n

.meas tran vdout0_30ck560 FIND v(dout0_30) AT=570.05n

.meas tran vdout0_31ck560 FIND v(dout0_31) AT=570.05n

.meas tran vdout0_0ck570 FIND v(dout0_0) AT=580.05n

.meas tran vdout0_1ck570 FIND v(dout0_1) AT=580.05n

.meas tran vdout0_2ck570 FIND v(dout0_2) AT=580.05n

.meas tran vdout0_3ck570 FIND v(dout0_3) AT=580.05n

.meas tran vdout0_4ck570 FIND v(dout0_4) AT=580.05n

.meas tran vdout0_5ck570 FIND v(dout0_5) AT=580.05n

.meas tran vdout0_6ck570 FIND v(dout0_6) AT=580.05n

.meas tran vdout0_7ck570 FIND v(dout0_7) AT=580.05n

.meas tran vdout0_8ck570 FIND v(dout0_8) AT=580.05n

.meas tran vdout0_9ck570 FIND v(dout0_9) AT=580.05n

.meas tran vdout0_10ck570 FIND v(dout0_10) AT=580.05n

.meas tran vdout0_11ck570 FIND v(dout0_11) AT=580.05n

.meas tran vdout0_12ck570 FIND v(dout0_12) AT=580.05n

.meas tran vdout0_13ck570 FIND v(dout0_13) AT=580.05n

.meas tran vdout0_14ck570 FIND v(dout0_14) AT=580.05n

.meas tran vdout0_15ck570 FIND v(dout0_15) AT=580.05n

.meas tran vdout0_16ck570 FIND v(dout0_16) AT=580.05n

.meas tran vdout0_17ck570 FIND v(dout0_17) AT=580.05n

.meas tran vdout0_18ck570 FIND v(dout0_18) AT=580.05n

.meas tran vdout0_19ck570 FIND v(dout0_19) AT=580.05n

.meas tran vdout0_20ck570 FIND v(dout0_20) AT=580.05n

.meas tran vdout0_21ck570 FIND v(dout0_21) AT=580.05n

.meas tran vdout0_22ck570 FIND v(dout0_22) AT=580.05n

.meas tran vdout0_23ck570 FIND v(dout0_23) AT=580.05n

.meas tran vdout0_24ck570 FIND v(dout0_24) AT=580.05n

.meas tran vdout0_25ck570 FIND v(dout0_25) AT=580.05n

.meas tran vdout0_26ck570 FIND v(dout0_26) AT=580.05n

.meas tran vdout0_27ck570 FIND v(dout0_27) AT=580.05n

.meas tran vdout0_28ck570 FIND v(dout0_28) AT=580.05n

.meas tran vdout0_29ck570 FIND v(dout0_29) AT=580.05n

.meas tran vdout0_30ck570 FIND v(dout0_30) AT=580.05n

.meas tran vdout0_31ck570 FIND v(dout0_31) AT=580.05n

.meas tran vdout0_0ck580 FIND v(dout0_0) AT=590.05n

.meas tran vdout0_1ck580 FIND v(dout0_1) AT=590.05n

.meas tran vdout0_2ck580 FIND v(dout0_2) AT=590.05n

.meas tran vdout0_3ck580 FIND v(dout0_3) AT=590.05n

.meas tran vdout0_4ck580 FIND v(dout0_4) AT=590.05n

.meas tran vdout0_5ck580 FIND v(dout0_5) AT=590.05n

.meas tran vdout0_6ck580 FIND v(dout0_6) AT=590.05n

.meas tran vdout0_7ck580 FIND v(dout0_7) AT=590.05n

.meas tran vdout0_8ck580 FIND v(dout0_8) AT=590.05n

.meas tran vdout0_9ck580 FIND v(dout0_9) AT=590.05n

.meas tran vdout0_10ck580 FIND v(dout0_10) AT=590.05n

.meas tran vdout0_11ck580 FIND v(dout0_11) AT=590.05n

.meas tran vdout0_12ck580 FIND v(dout0_12) AT=590.05n

.meas tran vdout0_13ck580 FIND v(dout0_13) AT=590.05n

.meas tran vdout0_14ck580 FIND v(dout0_14) AT=590.05n

.meas tran vdout0_15ck580 FIND v(dout0_15) AT=590.05n

.meas tran vdout0_16ck580 FIND v(dout0_16) AT=590.05n

.meas tran vdout0_17ck580 FIND v(dout0_17) AT=590.05n

.meas tran vdout0_18ck580 FIND v(dout0_18) AT=590.05n

.meas tran vdout0_19ck580 FIND v(dout0_19) AT=590.05n

.meas tran vdout0_20ck580 FIND v(dout0_20) AT=590.05n

.meas tran vdout0_21ck580 FIND v(dout0_21) AT=590.05n

.meas tran vdout0_22ck580 FIND v(dout0_22) AT=590.05n

.meas tran vdout0_23ck580 FIND v(dout0_23) AT=590.05n

.meas tran vdout0_24ck580 FIND v(dout0_24) AT=590.05n

.meas tran vdout0_25ck580 FIND v(dout0_25) AT=590.05n

.meas tran vdout0_26ck580 FIND v(dout0_26) AT=590.05n

.meas tran vdout0_27ck580 FIND v(dout0_27) AT=590.05n

.meas tran vdout0_28ck580 FIND v(dout0_28) AT=590.05n

.meas tran vdout0_29ck580 FIND v(dout0_29) AT=590.05n

.meas tran vdout0_30ck580 FIND v(dout0_30) AT=590.05n

.meas tran vdout0_31ck580 FIND v(dout0_31) AT=590.05n

.meas tran vdout0_0ck620 FIND v(dout0_0) AT=630.05n

.meas tran vdout0_1ck620 FIND v(dout0_1) AT=630.05n

.meas tran vdout0_2ck620 FIND v(dout0_2) AT=630.05n

.meas tran vdout0_3ck620 FIND v(dout0_3) AT=630.05n

.meas tran vdout0_4ck620 FIND v(dout0_4) AT=630.05n

.meas tran vdout0_5ck620 FIND v(dout0_5) AT=630.05n

.meas tran vdout0_6ck620 FIND v(dout0_6) AT=630.05n

.meas tran vdout0_7ck620 FIND v(dout0_7) AT=630.05n

.meas tran vdout0_8ck620 FIND v(dout0_8) AT=630.05n

.meas tran vdout0_9ck620 FIND v(dout0_9) AT=630.05n

.meas tran vdout0_10ck620 FIND v(dout0_10) AT=630.05n

.meas tran vdout0_11ck620 FIND v(dout0_11) AT=630.05n

.meas tran vdout0_12ck620 FIND v(dout0_12) AT=630.05n

.meas tran vdout0_13ck620 FIND v(dout0_13) AT=630.05n

.meas tran vdout0_14ck620 FIND v(dout0_14) AT=630.05n

.meas tran vdout0_15ck620 FIND v(dout0_15) AT=630.05n

.meas tran vdout0_16ck620 FIND v(dout0_16) AT=630.05n

.meas tran vdout0_17ck620 FIND v(dout0_17) AT=630.05n

.meas tran vdout0_18ck620 FIND v(dout0_18) AT=630.05n

.meas tran vdout0_19ck620 FIND v(dout0_19) AT=630.05n

.meas tran vdout0_20ck620 FIND v(dout0_20) AT=630.05n

.meas tran vdout0_21ck620 FIND v(dout0_21) AT=630.05n

.meas tran vdout0_22ck620 FIND v(dout0_22) AT=630.05n

.meas tran vdout0_23ck620 FIND v(dout0_23) AT=630.05n

.meas tran vdout0_24ck620 FIND v(dout0_24) AT=630.05n

.meas tran vdout0_25ck620 FIND v(dout0_25) AT=630.05n

.meas tran vdout0_26ck620 FIND v(dout0_26) AT=630.05n

.meas tran vdout0_27ck620 FIND v(dout0_27) AT=630.05n

.meas tran vdout0_28ck620 FIND v(dout0_28) AT=630.05n

.meas tran vdout0_29ck620 FIND v(dout0_29) AT=630.05n

.meas tran vdout0_30ck620 FIND v(dout0_30) AT=630.05n

.meas tran vdout0_31ck620 FIND v(dout0_31) AT=630.05n

.meas tran vdout0_0ck630 FIND v(dout0_0) AT=640.05n

.meas tran vdout0_1ck630 FIND v(dout0_1) AT=640.05n

.meas tran vdout0_2ck630 FIND v(dout0_2) AT=640.05n

.meas tran vdout0_3ck630 FIND v(dout0_3) AT=640.05n

.meas tran vdout0_4ck630 FIND v(dout0_4) AT=640.05n

.meas tran vdout0_5ck630 FIND v(dout0_5) AT=640.05n

.meas tran vdout0_6ck630 FIND v(dout0_6) AT=640.05n

.meas tran vdout0_7ck630 FIND v(dout0_7) AT=640.05n

.meas tran vdout0_8ck630 FIND v(dout0_8) AT=640.05n

.meas tran vdout0_9ck630 FIND v(dout0_9) AT=640.05n

.meas tran vdout0_10ck630 FIND v(dout0_10) AT=640.05n

.meas tran vdout0_11ck630 FIND v(dout0_11) AT=640.05n

.meas tran vdout0_12ck630 FIND v(dout0_12) AT=640.05n

.meas tran vdout0_13ck630 FIND v(dout0_13) AT=640.05n

.meas tran vdout0_14ck630 FIND v(dout0_14) AT=640.05n

.meas tran vdout0_15ck630 FIND v(dout0_15) AT=640.05n

.meas tran vdout0_16ck630 FIND v(dout0_16) AT=640.05n

.meas tran vdout0_17ck630 FIND v(dout0_17) AT=640.05n

.meas tran vdout0_18ck630 FIND v(dout0_18) AT=640.05n

.meas tran vdout0_19ck630 FIND v(dout0_19) AT=640.05n

.meas tran vdout0_20ck630 FIND v(dout0_20) AT=640.05n

.meas tran vdout0_21ck630 FIND v(dout0_21) AT=640.05n

.meas tran vdout0_22ck630 FIND v(dout0_22) AT=640.05n

.meas tran vdout0_23ck630 FIND v(dout0_23) AT=640.05n

.meas tran vdout0_24ck630 FIND v(dout0_24) AT=640.05n

.meas tran vdout0_25ck630 FIND v(dout0_25) AT=640.05n

.meas tran vdout0_26ck630 FIND v(dout0_26) AT=640.05n

.meas tran vdout0_27ck630 FIND v(dout0_27) AT=640.05n

.meas tran vdout0_28ck630 FIND v(dout0_28) AT=640.05n

.meas tran vdout0_29ck630 FIND v(dout0_29) AT=640.05n

.meas tran vdout0_30ck630 FIND v(dout0_30) AT=640.05n

.meas tran vdout0_31ck630 FIND v(dout0_31) AT=640.05n

.meas tran vdout0_0ck650 FIND v(dout0_0) AT=660.05n

.meas tran vdout0_1ck650 FIND v(dout0_1) AT=660.05n

.meas tran vdout0_2ck650 FIND v(dout0_2) AT=660.05n

.meas tran vdout0_3ck650 FIND v(dout0_3) AT=660.05n

.meas tran vdout0_4ck650 FIND v(dout0_4) AT=660.05n

.meas tran vdout0_5ck650 FIND v(dout0_5) AT=660.05n

.meas tran vdout0_6ck650 FIND v(dout0_6) AT=660.05n

.meas tran vdout0_7ck650 FIND v(dout0_7) AT=660.05n

.meas tran vdout0_8ck650 FIND v(dout0_8) AT=660.05n

.meas tran vdout0_9ck650 FIND v(dout0_9) AT=660.05n

.meas tran vdout0_10ck650 FIND v(dout0_10) AT=660.05n

.meas tran vdout0_11ck650 FIND v(dout0_11) AT=660.05n

.meas tran vdout0_12ck650 FIND v(dout0_12) AT=660.05n

.meas tran vdout0_13ck650 FIND v(dout0_13) AT=660.05n

.meas tran vdout0_14ck650 FIND v(dout0_14) AT=660.05n

.meas tran vdout0_15ck650 FIND v(dout0_15) AT=660.05n

.meas tran vdout0_16ck650 FIND v(dout0_16) AT=660.05n

.meas tran vdout0_17ck650 FIND v(dout0_17) AT=660.05n

.meas tran vdout0_18ck650 FIND v(dout0_18) AT=660.05n

.meas tran vdout0_19ck650 FIND v(dout0_19) AT=660.05n

.meas tran vdout0_20ck650 FIND v(dout0_20) AT=660.05n

.meas tran vdout0_21ck650 FIND v(dout0_21) AT=660.05n

.meas tran vdout0_22ck650 FIND v(dout0_22) AT=660.05n

.meas tran vdout0_23ck650 FIND v(dout0_23) AT=660.05n

.meas tran vdout0_24ck650 FIND v(dout0_24) AT=660.05n

.meas tran vdout0_25ck650 FIND v(dout0_25) AT=660.05n

.meas tran vdout0_26ck650 FIND v(dout0_26) AT=660.05n

.meas tran vdout0_27ck650 FIND v(dout0_27) AT=660.05n

.meas tran vdout0_28ck650 FIND v(dout0_28) AT=660.05n

.meas tran vdout0_29ck650 FIND v(dout0_29) AT=660.05n

.meas tran vdout0_30ck650 FIND v(dout0_30) AT=660.05n

.meas tran vdout0_31ck650 FIND v(dout0_31) AT=660.05n

.meas tran vdout0_0ck690 FIND v(dout0_0) AT=700.05n

.meas tran vdout0_1ck690 FIND v(dout0_1) AT=700.05n

.meas tran vdout0_2ck690 FIND v(dout0_2) AT=700.05n

.meas tran vdout0_3ck690 FIND v(dout0_3) AT=700.05n

.meas tran vdout0_4ck690 FIND v(dout0_4) AT=700.05n

.meas tran vdout0_5ck690 FIND v(dout0_5) AT=700.05n

.meas tran vdout0_6ck690 FIND v(dout0_6) AT=700.05n

.meas tran vdout0_7ck690 FIND v(dout0_7) AT=700.05n

.meas tran vdout0_8ck690 FIND v(dout0_8) AT=700.05n

.meas tran vdout0_9ck690 FIND v(dout0_9) AT=700.05n

.meas tran vdout0_10ck690 FIND v(dout0_10) AT=700.05n

.meas tran vdout0_11ck690 FIND v(dout0_11) AT=700.05n

.meas tran vdout0_12ck690 FIND v(dout0_12) AT=700.05n

.meas tran vdout0_13ck690 FIND v(dout0_13) AT=700.05n

.meas tran vdout0_14ck690 FIND v(dout0_14) AT=700.05n

.meas tran vdout0_15ck690 FIND v(dout0_15) AT=700.05n

.meas tran vdout0_16ck690 FIND v(dout0_16) AT=700.05n

.meas tran vdout0_17ck690 FIND v(dout0_17) AT=700.05n

.meas tran vdout0_18ck690 FIND v(dout0_18) AT=700.05n

.meas tran vdout0_19ck690 FIND v(dout0_19) AT=700.05n

.meas tran vdout0_20ck690 FIND v(dout0_20) AT=700.05n

.meas tran vdout0_21ck690 FIND v(dout0_21) AT=700.05n

.meas tran vdout0_22ck690 FIND v(dout0_22) AT=700.05n

.meas tran vdout0_23ck690 FIND v(dout0_23) AT=700.05n

.meas tran vdout0_24ck690 FIND v(dout0_24) AT=700.05n

.meas tran vdout0_25ck690 FIND v(dout0_25) AT=700.05n

.meas tran vdout0_26ck690 FIND v(dout0_26) AT=700.05n

.meas tran vdout0_27ck690 FIND v(dout0_27) AT=700.05n

.meas tran vdout0_28ck690 FIND v(dout0_28) AT=700.05n

.meas tran vdout0_29ck690 FIND v(dout0_29) AT=700.05n

.meas tran vdout0_30ck690 FIND v(dout0_30) AT=700.05n

.meas tran vdout0_31ck690 FIND v(dout0_31) AT=700.05n

.meas tran vdout0_0ck710 FIND v(dout0_0) AT=720.05n

.meas tran vdout0_1ck710 FIND v(dout0_1) AT=720.05n

.meas tran vdout0_2ck710 FIND v(dout0_2) AT=720.05n

.meas tran vdout0_3ck710 FIND v(dout0_3) AT=720.05n

.meas tran vdout0_4ck710 FIND v(dout0_4) AT=720.05n

.meas tran vdout0_5ck710 FIND v(dout0_5) AT=720.05n

.meas tran vdout0_6ck710 FIND v(dout0_6) AT=720.05n

.meas tran vdout0_7ck710 FIND v(dout0_7) AT=720.05n

.meas tran vdout0_8ck710 FIND v(dout0_8) AT=720.05n

.meas tran vdout0_9ck710 FIND v(dout0_9) AT=720.05n

.meas tran vdout0_10ck710 FIND v(dout0_10) AT=720.05n

.meas tran vdout0_11ck710 FIND v(dout0_11) AT=720.05n

.meas tran vdout0_12ck710 FIND v(dout0_12) AT=720.05n

.meas tran vdout0_13ck710 FIND v(dout0_13) AT=720.05n

.meas tran vdout0_14ck710 FIND v(dout0_14) AT=720.05n

.meas tran vdout0_15ck710 FIND v(dout0_15) AT=720.05n

.meas tran vdout0_16ck710 FIND v(dout0_16) AT=720.05n

.meas tran vdout0_17ck710 FIND v(dout0_17) AT=720.05n

.meas tran vdout0_18ck710 FIND v(dout0_18) AT=720.05n

.meas tran vdout0_19ck710 FIND v(dout0_19) AT=720.05n

.meas tran vdout0_20ck710 FIND v(dout0_20) AT=720.05n

.meas tran vdout0_21ck710 FIND v(dout0_21) AT=720.05n

.meas tran vdout0_22ck710 FIND v(dout0_22) AT=720.05n

.meas tran vdout0_23ck710 FIND v(dout0_23) AT=720.05n

.meas tran vdout0_24ck710 FIND v(dout0_24) AT=720.05n

.meas tran vdout0_25ck710 FIND v(dout0_25) AT=720.05n

.meas tran vdout0_26ck710 FIND v(dout0_26) AT=720.05n

.meas tran vdout0_27ck710 FIND v(dout0_27) AT=720.05n

.meas tran vdout0_28ck710 FIND v(dout0_28) AT=720.05n

.meas tran vdout0_29ck710 FIND v(dout0_29) AT=720.05n

.meas tran vdout0_30ck710 FIND v(dout0_30) AT=720.05n

.meas tran vdout0_31ck710 FIND v(dout0_31) AT=720.05n

.meas tran vdout0_0ck770 FIND v(dout0_0) AT=780.05n

.meas tran vdout0_1ck770 FIND v(dout0_1) AT=780.05n

.meas tran vdout0_2ck770 FIND v(dout0_2) AT=780.05n

.meas tran vdout0_3ck770 FIND v(dout0_3) AT=780.05n

.meas tran vdout0_4ck770 FIND v(dout0_4) AT=780.05n

.meas tran vdout0_5ck770 FIND v(dout0_5) AT=780.05n

.meas tran vdout0_6ck770 FIND v(dout0_6) AT=780.05n

.meas tran vdout0_7ck770 FIND v(dout0_7) AT=780.05n

.meas tran vdout0_8ck770 FIND v(dout0_8) AT=780.05n

.meas tran vdout0_9ck770 FIND v(dout0_9) AT=780.05n

.meas tran vdout0_10ck770 FIND v(dout0_10) AT=780.05n

.meas tran vdout0_11ck770 FIND v(dout0_11) AT=780.05n

.meas tran vdout0_12ck770 FIND v(dout0_12) AT=780.05n

.meas tran vdout0_13ck770 FIND v(dout0_13) AT=780.05n

.meas tran vdout0_14ck770 FIND v(dout0_14) AT=780.05n

.meas tran vdout0_15ck770 FIND v(dout0_15) AT=780.05n

.meas tran vdout0_16ck770 FIND v(dout0_16) AT=780.05n

.meas tran vdout0_17ck770 FIND v(dout0_17) AT=780.05n

.meas tran vdout0_18ck770 FIND v(dout0_18) AT=780.05n

.meas tran vdout0_19ck770 FIND v(dout0_19) AT=780.05n

.meas tran vdout0_20ck770 FIND v(dout0_20) AT=780.05n

.meas tran vdout0_21ck770 FIND v(dout0_21) AT=780.05n

.meas tran vdout0_22ck770 FIND v(dout0_22) AT=780.05n

.meas tran vdout0_23ck770 FIND v(dout0_23) AT=780.05n

.meas tran vdout0_24ck770 FIND v(dout0_24) AT=780.05n

.meas tran vdout0_25ck770 FIND v(dout0_25) AT=780.05n

.meas tran vdout0_26ck770 FIND v(dout0_26) AT=780.05n

.meas tran vdout0_27ck770 FIND v(dout0_27) AT=780.05n

.meas tran vdout0_28ck770 FIND v(dout0_28) AT=780.05n

.meas tran vdout0_29ck770 FIND v(dout0_29) AT=780.05n

.meas tran vdout0_30ck770 FIND v(dout0_30) AT=780.05n

.meas tran vdout0_31ck770 FIND v(dout0_31) AT=780.05n

.meas tran vdout0_0ck790 FIND v(dout0_0) AT=800.05n

.meas tran vdout0_1ck790 FIND v(dout0_1) AT=800.05n

.meas tran vdout0_2ck790 FIND v(dout0_2) AT=800.05n

.meas tran vdout0_3ck790 FIND v(dout0_3) AT=800.05n

.meas tran vdout0_4ck790 FIND v(dout0_4) AT=800.05n

.meas tran vdout0_5ck790 FIND v(dout0_5) AT=800.05n

.meas tran vdout0_6ck790 FIND v(dout0_6) AT=800.05n

.meas tran vdout0_7ck790 FIND v(dout0_7) AT=800.05n

.meas tran vdout0_8ck790 FIND v(dout0_8) AT=800.05n

.meas tran vdout0_9ck790 FIND v(dout0_9) AT=800.05n

.meas tran vdout0_10ck790 FIND v(dout0_10) AT=800.05n

.meas tran vdout0_11ck790 FIND v(dout0_11) AT=800.05n

.meas tran vdout0_12ck790 FIND v(dout0_12) AT=800.05n

.meas tran vdout0_13ck790 FIND v(dout0_13) AT=800.05n

.meas tran vdout0_14ck790 FIND v(dout0_14) AT=800.05n

.meas tran vdout0_15ck790 FIND v(dout0_15) AT=800.05n

.meas tran vdout0_16ck790 FIND v(dout0_16) AT=800.05n

.meas tran vdout0_17ck790 FIND v(dout0_17) AT=800.05n

.meas tran vdout0_18ck790 FIND v(dout0_18) AT=800.05n

.meas tran vdout0_19ck790 FIND v(dout0_19) AT=800.05n

.meas tran vdout0_20ck790 FIND v(dout0_20) AT=800.05n

.meas tran vdout0_21ck790 FIND v(dout0_21) AT=800.05n

.meas tran vdout0_22ck790 FIND v(dout0_22) AT=800.05n

.meas tran vdout0_23ck790 FIND v(dout0_23) AT=800.05n

.meas tran vdout0_24ck790 FIND v(dout0_24) AT=800.05n

.meas tran vdout0_25ck790 FIND v(dout0_25) AT=800.05n

.meas tran vdout0_26ck790 FIND v(dout0_26) AT=800.05n

.meas tran vdout0_27ck790 FIND v(dout0_27) AT=800.05n

.meas tran vdout0_28ck790 FIND v(dout0_28) AT=800.05n

.meas tran vdout0_29ck790 FIND v(dout0_29) AT=800.05n

.meas tran vdout0_30ck790 FIND v(dout0_30) AT=800.05n

.meas tran vdout0_31ck790 FIND v(dout0_31) AT=800.05n

.meas tran vdout0_0ck800 FIND v(dout0_0) AT=810.05n

.meas tran vdout0_1ck800 FIND v(dout0_1) AT=810.05n

.meas tran vdout0_2ck800 FIND v(dout0_2) AT=810.05n

.meas tran vdout0_3ck800 FIND v(dout0_3) AT=810.05n

.meas tran vdout0_4ck800 FIND v(dout0_4) AT=810.05n

.meas tran vdout0_5ck800 FIND v(dout0_5) AT=810.05n

.meas tran vdout0_6ck800 FIND v(dout0_6) AT=810.05n

.meas tran vdout0_7ck800 FIND v(dout0_7) AT=810.05n

.meas tran vdout0_8ck800 FIND v(dout0_8) AT=810.05n

.meas tran vdout0_9ck800 FIND v(dout0_9) AT=810.05n

.meas tran vdout0_10ck800 FIND v(dout0_10) AT=810.05n

.meas tran vdout0_11ck800 FIND v(dout0_11) AT=810.05n

.meas tran vdout0_12ck800 FIND v(dout0_12) AT=810.05n

.meas tran vdout0_13ck800 FIND v(dout0_13) AT=810.05n

.meas tran vdout0_14ck800 FIND v(dout0_14) AT=810.05n

.meas tran vdout0_15ck800 FIND v(dout0_15) AT=810.05n

.meas tran vdout0_16ck800 FIND v(dout0_16) AT=810.05n

.meas tran vdout0_17ck800 FIND v(dout0_17) AT=810.05n

.meas tran vdout0_18ck800 FIND v(dout0_18) AT=810.05n

.meas tran vdout0_19ck800 FIND v(dout0_19) AT=810.05n

.meas tran vdout0_20ck800 FIND v(dout0_20) AT=810.05n

.meas tran vdout0_21ck800 FIND v(dout0_21) AT=810.05n

.meas tran vdout0_22ck800 FIND v(dout0_22) AT=810.05n

.meas tran vdout0_23ck800 FIND v(dout0_23) AT=810.05n

.meas tran vdout0_24ck800 FIND v(dout0_24) AT=810.05n

.meas tran vdout0_25ck800 FIND v(dout0_25) AT=810.05n

.meas tran vdout0_26ck800 FIND v(dout0_26) AT=810.05n

.meas tran vdout0_27ck800 FIND v(dout0_27) AT=810.05n

.meas tran vdout0_28ck800 FIND v(dout0_28) AT=810.05n

.meas tran vdout0_29ck800 FIND v(dout0_29) AT=810.05n

.meas tran vdout0_30ck800 FIND v(dout0_30) AT=810.05n

.meas tran vdout0_31ck800 FIND v(dout0_31) AT=810.05n

.meas tran vdout0_0ck810 FIND v(dout0_0) AT=820.05n

.meas tran vdout0_1ck810 FIND v(dout0_1) AT=820.05n

.meas tran vdout0_2ck810 FIND v(dout0_2) AT=820.05n

.meas tran vdout0_3ck810 FIND v(dout0_3) AT=820.05n

.meas tran vdout0_4ck810 FIND v(dout0_4) AT=820.05n

.meas tran vdout0_5ck810 FIND v(dout0_5) AT=820.05n

.meas tran vdout0_6ck810 FIND v(dout0_6) AT=820.05n

.meas tran vdout0_7ck810 FIND v(dout0_7) AT=820.05n

.meas tran vdout0_8ck810 FIND v(dout0_8) AT=820.05n

.meas tran vdout0_9ck810 FIND v(dout0_9) AT=820.05n

.meas tran vdout0_10ck810 FIND v(dout0_10) AT=820.05n

.meas tran vdout0_11ck810 FIND v(dout0_11) AT=820.05n

.meas tran vdout0_12ck810 FIND v(dout0_12) AT=820.05n

.meas tran vdout0_13ck810 FIND v(dout0_13) AT=820.05n

.meas tran vdout0_14ck810 FIND v(dout0_14) AT=820.05n

.meas tran vdout0_15ck810 FIND v(dout0_15) AT=820.05n

.meas tran vdout0_16ck810 FIND v(dout0_16) AT=820.05n

.meas tran vdout0_17ck810 FIND v(dout0_17) AT=820.05n

.meas tran vdout0_18ck810 FIND v(dout0_18) AT=820.05n

.meas tran vdout0_19ck810 FIND v(dout0_19) AT=820.05n

.meas tran vdout0_20ck810 FIND v(dout0_20) AT=820.05n

.meas tran vdout0_21ck810 FIND v(dout0_21) AT=820.05n

.meas tran vdout0_22ck810 FIND v(dout0_22) AT=820.05n

.meas tran vdout0_23ck810 FIND v(dout0_23) AT=820.05n

.meas tran vdout0_24ck810 FIND v(dout0_24) AT=820.05n

.meas tran vdout0_25ck810 FIND v(dout0_25) AT=820.05n

.meas tran vdout0_26ck810 FIND v(dout0_26) AT=820.05n

.meas tran vdout0_27ck810 FIND v(dout0_27) AT=820.05n

.meas tran vdout0_28ck810 FIND v(dout0_28) AT=820.05n

.meas tran vdout0_29ck810 FIND v(dout0_29) AT=820.05n

.meas tran vdout0_30ck810 FIND v(dout0_30) AT=820.05n

.meas tran vdout0_31ck810 FIND v(dout0_31) AT=820.05n

.meas tran vdout0_0ck830 FIND v(dout0_0) AT=840.05n

.meas tran vdout0_1ck830 FIND v(dout0_1) AT=840.05n

.meas tran vdout0_2ck830 FIND v(dout0_2) AT=840.05n

.meas tran vdout0_3ck830 FIND v(dout0_3) AT=840.05n

.meas tran vdout0_4ck830 FIND v(dout0_4) AT=840.05n

.meas tran vdout0_5ck830 FIND v(dout0_5) AT=840.05n

.meas tran vdout0_6ck830 FIND v(dout0_6) AT=840.05n

.meas tran vdout0_7ck830 FIND v(dout0_7) AT=840.05n

.meas tran vdout0_8ck830 FIND v(dout0_8) AT=840.05n

.meas tran vdout0_9ck830 FIND v(dout0_9) AT=840.05n

.meas tran vdout0_10ck830 FIND v(dout0_10) AT=840.05n

.meas tran vdout0_11ck830 FIND v(dout0_11) AT=840.05n

.meas tran vdout0_12ck830 FIND v(dout0_12) AT=840.05n

.meas tran vdout0_13ck830 FIND v(dout0_13) AT=840.05n

.meas tran vdout0_14ck830 FIND v(dout0_14) AT=840.05n

.meas tran vdout0_15ck830 FIND v(dout0_15) AT=840.05n

.meas tran vdout0_16ck830 FIND v(dout0_16) AT=840.05n

.meas tran vdout0_17ck830 FIND v(dout0_17) AT=840.05n

.meas tran vdout0_18ck830 FIND v(dout0_18) AT=840.05n

.meas tran vdout0_19ck830 FIND v(dout0_19) AT=840.05n

.meas tran vdout0_20ck830 FIND v(dout0_20) AT=840.05n

.meas tran vdout0_21ck830 FIND v(dout0_21) AT=840.05n

.meas tran vdout0_22ck830 FIND v(dout0_22) AT=840.05n

.meas tran vdout0_23ck830 FIND v(dout0_23) AT=840.05n

.meas tran vdout0_24ck830 FIND v(dout0_24) AT=840.05n

.meas tran vdout0_25ck830 FIND v(dout0_25) AT=840.05n

.meas tran vdout0_26ck830 FIND v(dout0_26) AT=840.05n

.meas tran vdout0_27ck830 FIND v(dout0_27) AT=840.05n

.meas tran vdout0_28ck830 FIND v(dout0_28) AT=840.05n

.meas tran vdout0_29ck830 FIND v(dout0_29) AT=840.05n

.meas tran vdout0_30ck830 FIND v(dout0_30) AT=840.05n

.meas tran vdout0_31ck830 FIND v(dout0_31) AT=840.05n

.meas tran vdout0_0ck840 FIND v(dout0_0) AT=850.05n

.meas tran vdout0_1ck840 FIND v(dout0_1) AT=850.05n

.meas tran vdout0_2ck840 FIND v(dout0_2) AT=850.05n

.meas tran vdout0_3ck840 FIND v(dout0_3) AT=850.05n

.meas tran vdout0_4ck840 FIND v(dout0_4) AT=850.05n

.meas tran vdout0_5ck840 FIND v(dout0_5) AT=850.05n

.meas tran vdout0_6ck840 FIND v(dout0_6) AT=850.05n

.meas tran vdout0_7ck840 FIND v(dout0_7) AT=850.05n

.meas tran vdout0_8ck840 FIND v(dout0_8) AT=850.05n

.meas tran vdout0_9ck840 FIND v(dout0_9) AT=850.05n

.meas tran vdout0_10ck840 FIND v(dout0_10) AT=850.05n

.meas tran vdout0_11ck840 FIND v(dout0_11) AT=850.05n

.meas tran vdout0_12ck840 FIND v(dout0_12) AT=850.05n

.meas tran vdout0_13ck840 FIND v(dout0_13) AT=850.05n

.meas tran vdout0_14ck840 FIND v(dout0_14) AT=850.05n

.meas tran vdout0_15ck840 FIND v(dout0_15) AT=850.05n

.meas tran vdout0_16ck840 FIND v(dout0_16) AT=850.05n

.meas tran vdout0_17ck840 FIND v(dout0_17) AT=850.05n

.meas tran vdout0_18ck840 FIND v(dout0_18) AT=850.05n

.meas tran vdout0_19ck840 FIND v(dout0_19) AT=850.05n

.meas tran vdout0_20ck840 FIND v(dout0_20) AT=850.05n

.meas tran vdout0_21ck840 FIND v(dout0_21) AT=850.05n

.meas tran vdout0_22ck840 FIND v(dout0_22) AT=850.05n

.meas tran vdout0_23ck840 FIND v(dout0_23) AT=850.05n

.meas tran vdout0_24ck840 FIND v(dout0_24) AT=850.05n

.meas tran vdout0_25ck840 FIND v(dout0_25) AT=850.05n

.meas tran vdout0_26ck840 FIND v(dout0_26) AT=850.05n

.meas tran vdout0_27ck840 FIND v(dout0_27) AT=850.05n

.meas tran vdout0_28ck840 FIND v(dout0_28) AT=850.05n

.meas tran vdout0_29ck840 FIND v(dout0_29) AT=850.05n

.meas tran vdout0_30ck840 FIND v(dout0_30) AT=850.05n

.meas tran vdout0_31ck840 FIND v(dout0_31) AT=850.05n

.meas tran vdout0_0ck860 FIND v(dout0_0) AT=870.05n

.meas tran vdout0_1ck860 FIND v(dout0_1) AT=870.05n

.meas tran vdout0_2ck860 FIND v(dout0_2) AT=870.05n

.meas tran vdout0_3ck860 FIND v(dout0_3) AT=870.05n

.meas tran vdout0_4ck860 FIND v(dout0_4) AT=870.05n

.meas tran vdout0_5ck860 FIND v(dout0_5) AT=870.05n

.meas tran vdout0_6ck860 FIND v(dout0_6) AT=870.05n

.meas tran vdout0_7ck860 FIND v(dout0_7) AT=870.05n

.meas tran vdout0_8ck860 FIND v(dout0_8) AT=870.05n

.meas tran vdout0_9ck860 FIND v(dout0_9) AT=870.05n

.meas tran vdout0_10ck860 FIND v(dout0_10) AT=870.05n

.meas tran vdout0_11ck860 FIND v(dout0_11) AT=870.05n

.meas tran vdout0_12ck860 FIND v(dout0_12) AT=870.05n

.meas tran vdout0_13ck860 FIND v(dout0_13) AT=870.05n

.meas tran vdout0_14ck860 FIND v(dout0_14) AT=870.05n

.meas tran vdout0_15ck860 FIND v(dout0_15) AT=870.05n

.meas tran vdout0_16ck860 FIND v(dout0_16) AT=870.05n

.meas tran vdout0_17ck860 FIND v(dout0_17) AT=870.05n

.meas tran vdout0_18ck860 FIND v(dout0_18) AT=870.05n

.meas tran vdout0_19ck860 FIND v(dout0_19) AT=870.05n

.meas tran vdout0_20ck860 FIND v(dout0_20) AT=870.05n

.meas tran vdout0_21ck860 FIND v(dout0_21) AT=870.05n

.meas tran vdout0_22ck860 FIND v(dout0_22) AT=870.05n

.meas tran vdout0_23ck860 FIND v(dout0_23) AT=870.05n

.meas tran vdout0_24ck860 FIND v(dout0_24) AT=870.05n

.meas tran vdout0_25ck860 FIND v(dout0_25) AT=870.05n

.meas tran vdout0_26ck860 FIND v(dout0_26) AT=870.05n

.meas tran vdout0_27ck860 FIND v(dout0_27) AT=870.05n

.meas tran vdout0_28ck860 FIND v(dout0_28) AT=870.05n

.meas tran vdout0_29ck860 FIND v(dout0_29) AT=870.05n

.meas tran vdout0_30ck860 FIND v(dout0_30) AT=870.05n

.meas tran vdout0_31ck860 FIND v(dout0_31) AT=870.05n

.meas tran vdout0_0ck890 FIND v(dout0_0) AT=900.05n

.meas tran vdout0_1ck890 FIND v(dout0_1) AT=900.05n

.meas tran vdout0_2ck890 FIND v(dout0_2) AT=900.05n

.meas tran vdout0_3ck890 FIND v(dout0_3) AT=900.05n

.meas tran vdout0_4ck890 FIND v(dout0_4) AT=900.05n

.meas tran vdout0_5ck890 FIND v(dout0_5) AT=900.05n

.meas tran vdout0_6ck890 FIND v(dout0_6) AT=900.05n

.meas tran vdout0_7ck890 FIND v(dout0_7) AT=900.05n

.meas tran vdout0_8ck890 FIND v(dout0_8) AT=900.05n

.meas tran vdout0_9ck890 FIND v(dout0_9) AT=900.05n

.meas tran vdout0_10ck890 FIND v(dout0_10) AT=900.05n

.meas tran vdout0_11ck890 FIND v(dout0_11) AT=900.05n

.meas tran vdout0_12ck890 FIND v(dout0_12) AT=900.05n

.meas tran vdout0_13ck890 FIND v(dout0_13) AT=900.05n

.meas tran vdout0_14ck890 FIND v(dout0_14) AT=900.05n

.meas tran vdout0_15ck890 FIND v(dout0_15) AT=900.05n

.meas tran vdout0_16ck890 FIND v(dout0_16) AT=900.05n

.meas tran vdout0_17ck890 FIND v(dout0_17) AT=900.05n

.meas tran vdout0_18ck890 FIND v(dout0_18) AT=900.05n

.meas tran vdout0_19ck890 FIND v(dout0_19) AT=900.05n

.meas tran vdout0_20ck890 FIND v(dout0_20) AT=900.05n

.meas tran vdout0_21ck890 FIND v(dout0_21) AT=900.05n

.meas tran vdout0_22ck890 FIND v(dout0_22) AT=900.05n

.meas tran vdout0_23ck890 FIND v(dout0_23) AT=900.05n

.meas tran vdout0_24ck890 FIND v(dout0_24) AT=900.05n

.meas tran vdout0_25ck890 FIND v(dout0_25) AT=900.05n

.meas tran vdout0_26ck890 FIND v(dout0_26) AT=900.05n

.meas tran vdout0_27ck890 FIND v(dout0_27) AT=900.05n

.meas tran vdout0_28ck890 FIND v(dout0_28) AT=900.05n

.meas tran vdout0_29ck890 FIND v(dout0_29) AT=900.05n

.meas tran vdout0_30ck890 FIND v(dout0_30) AT=900.05n

.meas tran vdout0_31ck890 FIND v(dout0_31) AT=900.05n

.meas tran vdout0_0ck900 FIND v(dout0_0) AT=910.05n

.meas tran vdout0_1ck900 FIND v(dout0_1) AT=910.05n

.meas tran vdout0_2ck900 FIND v(dout0_2) AT=910.05n

.meas tran vdout0_3ck900 FIND v(dout0_3) AT=910.05n

.meas tran vdout0_4ck900 FIND v(dout0_4) AT=910.05n

.meas tran vdout0_5ck900 FIND v(dout0_5) AT=910.05n

.meas tran vdout0_6ck900 FIND v(dout0_6) AT=910.05n

.meas tran vdout0_7ck900 FIND v(dout0_7) AT=910.05n

.meas tran vdout0_8ck900 FIND v(dout0_8) AT=910.05n

.meas tran vdout0_9ck900 FIND v(dout0_9) AT=910.05n

.meas tran vdout0_10ck900 FIND v(dout0_10) AT=910.05n

.meas tran vdout0_11ck900 FIND v(dout0_11) AT=910.05n

.meas tran vdout0_12ck900 FIND v(dout0_12) AT=910.05n

.meas tran vdout0_13ck900 FIND v(dout0_13) AT=910.05n

.meas tran vdout0_14ck900 FIND v(dout0_14) AT=910.05n

.meas tran vdout0_15ck900 FIND v(dout0_15) AT=910.05n

.meas tran vdout0_16ck900 FIND v(dout0_16) AT=910.05n

.meas tran vdout0_17ck900 FIND v(dout0_17) AT=910.05n

.meas tran vdout0_18ck900 FIND v(dout0_18) AT=910.05n

.meas tran vdout0_19ck900 FIND v(dout0_19) AT=910.05n

.meas tran vdout0_20ck900 FIND v(dout0_20) AT=910.05n

.meas tran vdout0_21ck900 FIND v(dout0_21) AT=910.05n

.meas tran vdout0_22ck900 FIND v(dout0_22) AT=910.05n

.meas tran vdout0_23ck900 FIND v(dout0_23) AT=910.05n

.meas tran vdout0_24ck900 FIND v(dout0_24) AT=910.05n

.meas tran vdout0_25ck900 FIND v(dout0_25) AT=910.05n

.meas tran vdout0_26ck900 FIND v(dout0_26) AT=910.05n

.meas tran vdout0_27ck900 FIND v(dout0_27) AT=910.05n

.meas tran vdout0_28ck900 FIND v(dout0_28) AT=910.05n

.meas tran vdout0_29ck900 FIND v(dout0_29) AT=910.05n

.meas tran vdout0_30ck900 FIND v(dout0_30) AT=910.05n

.meas tran vdout0_31ck900 FIND v(dout0_31) AT=910.05n

.meas tran vdout0_0ck930 FIND v(dout0_0) AT=940.05n

.meas tran vdout0_1ck930 FIND v(dout0_1) AT=940.05n

.meas tran vdout0_2ck930 FIND v(dout0_2) AT=940.05n

.meas tran vdout0_3ck930 FIND v(dout0_3) AT=940.05n

.meas tran vdout0_4ck930 FIND v(dout0_4) AT=940.05n

.meas tran vdout0_5ck930 FIND v(dout0_5) AT=940.05n

.meas tran vdout0_6ck930 FIND v(dout0_6) AT=940.05n

.meas tran vdout0_7ck930 FIND v(dout0_7) AT=940.05n

.meas tran vdout0_8ck930 FIND v(dout0_8) AT=940.05n

.meas tran vdout0_9ck930 FIND v(dout0_9) AT=940.05n

.meas tran vdout0_10ck930 FIND v(dout0_10) AT=940.05n

.meas tran vdout0_11ck930 FIND v(dout0_11) AT=940.05n

.meas tran vdout0_12ck930 FIND v(dout0_12) AT=940.05n

.meas tran vdout0_13ck930 FIND v(dout0_13) AT=940.05n

.meas tran vdout0_14ck930 FIND v(dout0_14) AT=940.05n

.meas tran vdout0_15ck930 FIND v(dout0_15) AT=940.05n

.meas tran vdout0_16ck930 FIND v(dout0_16) AT=940.05n

.meas tran vdout0_17ck930 FIND v(dout0_17) AT=940.05n

.meas tran vdout0_18ck930 FIND v(dout0_18) AT=940.05n

.meas tran vdout0_19ck930 FIND v(dout0_19) AT=940.05n

.meas tran vdout0_20ck930 FIND v(dout0_20) AT=940.05n

.meas tran vdout0_21ck930 FIND v(dout0_21) AT=940.05n

.meas tran vdout0_22ck930 FIND v(dout0_22) AT=940.05n

.meas tran vdout0_23ck930 FIND v(dout0_23) AT=940.05n

.meas tran vdout0_24ck930 FIND v(dout0_24) AT=940.05n

.meas tran vdout0_25ck930 FIND v(dout0_25) AT=940.05n

.meas tran vdout0_26ck930 FIND v(dout0_26) AT=940.05n

.meas tran vdout0_27ck930 FIND v(dout0_27) AT=940.05n

.meas tran vdout0_28ck930 FIND v(dout0_28) AT=940.05n

.meas tran vdout0_29ck930 FIND v(dout0_29) AT=940.05n

.meas tran vdout0_30ck930 FIND v(dout0_30) AT=940.05n

.meas tran vdout0_31ck930 FIND v(dout0_31) AT=940.05n

.meas tran vdout0_0ck960 FIND v(dout0_0) AT=970.05n

.meas tran vdout0_1ck960 FIND v(dout0_1) AT=970.05n

.meas tran vdout0_2ck960 FIND v(dout0_2) AT=970.05n

.meas tran vdout0_3ck960 FIND v(dout0_3) AT=970.05n

.meas tran vdout0_4ck960 FIND v(dout0_4) AT=970.05n

.meas tran vdout0_5ck960 FIND v(dout0_5) AT=970.05n

.meas tran vdout0_6ck960 FIND v(dout0_6) AT=970.05n

.meas tran vdout0_7ck960 FIND v(dout0_7) AT=970.05n

.meas tran vdout0_8ck960 FIND v(dout0_8) AT=970.05n

.meas tran vdout0_9ck960 FIND v(dout0_9) AT=970.05n

.meas tran vdout0_10ck960 FIND v(dout0_10) AT=970.05n

.meas tran vdout0_11ck960 FIND v(dout0_11) AT=970.05n

.meas tran vdout0_12ck960 FIND v(dout0_12) AT=970.05n

.meas tran vdout0_13ck960 FIND v(dout0_13) AT=970.05n

.meas tran vdout0_14ck960 FIND v(dout0_14) AT=970.05n

.meas tran vdout0_15ck960 FIND v(dout0_15) AT=970.05n

.meas tran vdout0_16ck960 FIND v(dout0_16) AT=970.05n

.meas tran vdout0_17ck960 FIND v(dout0_17) AT=970.05n

.meas tran vdout0_18ck960 FIND v(dout0_18) AT=970.05n

.meas tran vdout0_19ck960 FIND v(dout0_19) AT=970.05n

.meas tran vdout0_20ck960 FIND v(dout0_20) AT=970.05n

.meas tran vdout0_21ck960 FIND v(dout0_21) AT=970.05n

.meas tran vdout0_22ck960 FIND v(dout0_22) AT=970.05n

.meas tran vdout0_23ck960 FIND v(dout0_23) AT=970.05n

.meas tran vdout0_24ck960 FIND v(dout0_24) AT=970.05n

.meas tran vdout0_25ck960 FIND v(dout0_25) AT=970.05n

.meas tran vdout0_26ck960 FIND v(dout0_26) AT=970.05n

.meas tran vdout0_27ck960 FIND v(dout0_27) AT=970.05n

.meas tran vdout0_28ck960 FIND v(dout0_28) AT=970.05n

.meas tran vdout0_29ck960 FIND v(dout0_29) AT=970.05n

.meas tran vdout0_30ck960 FIND v(dout0_30) AT=970.05n

.meas tran vdout0_31ck960 FIND v(dout0_31) AT=970.05n

.meas tran vdout0_0ck980 FIND v(dout0_0) AT=990.05n

.meas tran vdout0_1ck980 FIND v(dout0_1) AT=990.05n

.meas tran vdout0_2ck980 FIND v(dout0_2) AT=990.05n

.meas tran vdout0_3ck980 FIND v(dout0_3) AT=990.05n

.meas tran vdout0_4ck980 FIND v(dout0_4) AT=990.05n

.meas tran vdout0_5ck980 FIND v(dout0_5) AT=990.05n

.meas tran vdout0_6ck980 FIND v(dout0_6) AT=990.05n

.meas tran vdout0_7ck980 FIND v(dout0_7) AT=990.05n

.meas tran vdout0_8ck980 FIND v(dout0_8) AT=990.05n

.meas tran vdout0_9ck980 FIND v(dout0_9) AT=990.05n

.meas tran vdout0_10ck980 FIND v(dout0_10) AT=990.05n

.meas tran vdout0_11ck980 FIND v(dout0_11) AT=990.05n

.meas tran vdout0_12ck980 FIND v(dout0_12) AT=990.05n

.meas tran vdout0_13ck980 FIND v(dout0_13) AT=990.05n

.meas tran vdout0_14ck980 FIND v(dout0_14) AT=990.05n

.meas tran vdout0_15ck980 FIND v(dout0_15) AT=990.05n

.meas tran vdout0_16ck980 FIND v(dout0_16) AT=990.05n

.meas tran vdout0_17ck980 FIND v(dout0_17) AT=990.05n

.meas tran vdout0_18ck980 FIND v(dout0_18) AT=990.05n

.meas tran vdout0_19ck980 FIND v(dout0_19) AT=990.05n

.meas tran vdout0_20ck980 FIND v(dout0_20) AT=990.05n

.meas tran vdout0_21ck980 FIND v(dout0_21) AT=990.05n

.meas tran vdout0_22ck980 FIND v(dout0_22) AT=990.05n

.meas tran vdout0_23ck980 FIND v(dout0_23) AT=990.05n

.meas tran vdout0_24ck980 FIND v(dout0_24) AT=990.05n

.meas tran vdout0_25ck980 FIND v(dout0_25) AT=990.05n

.meas tran vdout0_26ck980 FIND v(dout0_26) AT=990.05n

.meas tran vdout0_27ck980 FIND v(dout0_27) AT=990.05n

.meas tran vdout0_28ck980 FIND v(dout0_28) AT=990.05n

.meas tran vdout0_29ck980 FIND v(dout0_29) AT=990.05n

.meas tran vdout0_30ck980 FIND v(dout0_30) AT=990.05n

.meas tran vdout0_31ck980 FIND v(dout0_31) AT=990.05n

.meas tran vdout0_0ck990 FIND v(dout0_0) AT=1000.05n

.meas tran vdout0_1ck990 FIND v(dout0_1) AT=1000.05n

.meas tran vdout0_2ck990 FIND v(dout0_2) AT=1000.05n

.meas tran vdout0_3ck990 FIND v(dout0_3) AT=1000.05n

.meas tran vdout0_4ck990 FIND v(dout0_4) AT=1000.05n

.meas tran vdout0_5ck990 FIND v(dout0_5) AT=1000.05n

.meas tran vdout0_6ck990 FIND v(dout0_6) AT=1000.05n

.meas tran vdout0_7ck990 FIND v(dout0_7) AT=1000.05n

.meas tran vdout0_8ck990 FIND v(dout0_8) AT=1000.05n

.meas tran vdout0_9ck990 FIND v(dout0_9) AT=1000.05n

.meas tran vdout0_10ck990 FIND v(dout0_10) AT=1000.05n

.meas tran vdout0_11ck990 FIND v(dout0_11) AT=1000.05n

.meas tran vdout0_12ck990 FIND v(dout0_12) AT=1000.05n

.meas tran vdout0_13ck990 FIND v(dout0_13) AT=1000.05n

.meas tran vdout0_14ck990 FIND v(dout0_14) AT=1000.05n

.meas tran vdout0_15ck990 FIND v(dout0_15) AT=1000.05n

.meas tran vdout0_16ck990 FIND v(dout0_16) AT=1000.05n

.meas tran vdout0_17ck990 FIND v(dout0_17) AT=1000.05n

.meas tran vdout0_18ck990 FIND v(dout0_18) AT=1000.05n

.meas tran vdout0_19ck990 FIND v(dout0_19) AT=1000.05n

.meas tran vdout0_20ck990 FIND v(dout0_20) AT=1000.05n

.meas tran vdout0_21ck990 FIND v(dout0_21) AT=1000.05n

.meas tran vdout0_22ck990 FIND v(dout0_22) AT=1000.05n

.meas tran vdout0_23ck990 FIND v(dout0_23) AT=1000.05n

.meas tran vdout0_24ck990 FIND v(dout0_24) AT=1000.05n

.meas tran vdout0_25ck990 FIND v(dout0_25) AT=1000.05n

.meas tran vdout0_26ck990 FIND v(dout0_26) AT=1000.05n

.meas tran vdout0_27ck990 FIND v(dout0_27) AT=1000.05n

.meas tran vdout0_28ck990 FIND v(dout0_28) AT=1000.05n

.meas tran vdout0_29ck990 FIND v(dout0_29) AT=1000.05n

.meas tran vdout0_30ck990 FIND v(dout0_30) AT=1000.05n

.meas tran vdout0_31ck990 FIND v(dout0_31) AT=1000.05n

.meas tran vdout0_0ck1010 FIND v(dout0_0) AT=1020.05n

.meas tran vdout0_1ck1010 FIND v(dout0_1) AT=1020.05n

.meas tran vdout0_2ck1010 FIND v(dout0_2) AT=1020.05n

.meas tran vdout0_3ck1010 FIND v(dout0_3) AT=1020.05n

.meas tran vdout0_4ck1010 FIND v(dout0_4) AT=1020.05n

.meas tran vdout0_5ck1010 FIND v(dout0_5) AT=1020.05n

.meas tran vdout0_6ck1010 FIND v(dout0_6) AT=1020.05n

.meas tran vdout0_7ck1010 FIND v(dout0_7) AT=1020.05n

.meas tran vdout0_8ck1010 FIND v(dout0_8) AT=1020.05n

.meas tran vdout0_9ck1010 FIND v(dout0_9) AT=1020.05n

.meas tran vdout0_10ck1010 FIND v(dout0_10) AT=1020.05n

.meas tran vdout0_11ck1010 FIND v(dout0_11) AT=1020.05n

.meas tran vdout0_12ck1010 FIND v(dout0_12) AT=1020.05n

.meas tran vdout0_13ck1010 FIND v(dout0_13) AT=1020.05n

.meas tran vdout0_14ck1010 FIND v(dout0_14) AT=1020.05n

.meas tran vdout0_15ck1010 FIND v(dout0_15) AT=1020.05n

.meas tran vdout0_16ck1010 FIND v(dout0_16) AT=1020.05n

.meas tran vdout0_17ck1010 FIND v(dout0_17) AT=1020.05n

.meas tran vdout0_18ck1010 FIND v(dout0_18) AT=1020.05n

.meas tran vdout0_19ck1010 FIND v(dout0_19) AT=1020.05n

.meas tran vdout0_20ck1010 FIND v(dout0_20) AT=1020.05n

.meas tran vdout0_21ck1010 FIND v(dout0_21) AT=1020.05n

.meas tran vdout0_22ck1010 FIND v(dout0_22) AT=1020.05n

.meas tran vdout0_23ck1010 FIND v(dout0_23) AT=1020.05n

.meas tran vdout0_24ck1010 FIND v(dout0_24) AT=1020.05n

.meas tran vdout0_25ck1010 FIND v(dout0_25) AT=1020.05n

.meas tran vdout0_26ck1010 FIND v(dout0_26) AT=1020.05n

.meas tran vdout0_27ck1010 FIND v(dout0_27) AT=1020.05n

.meas tran vdout0_28ck1010 FIND v(dout0_28) AT=1020.05n

.meas tran vdout0_29ck1010 FIND v(dout0_29) AT=1020.05n

.meas tran vdout0_30ck1010 FIND v(dout0_30) AT=1020.05n

.meas tran vdout0_31ck1010 FIND v(dout0_31) AT=1020.05n

.meas tran vdout0_0ck1030 FIND v(dout0_0) AT=1040.05n

.meas tran vdout0_1ck1030 FIND v(dout0_1) AT=1040.05n

.meas tran vdout0_2ck1030 FIND v(dout0_2) AT=1040.05n

.meas tran vdout0_3ck1030 FIND v(dout0_3) AT=1040.05n

.meas tran vdout0_4ck1030 FIND v(dout0_4) AT=1040.05n

.meas tran vdout0_5ck1030 FIND v(dout0_5) AT=1040.05n

.meas tran vdout0_6ck1030 FIND v(dout0_6) AT=1040.05n

.meas tran vdout0_7ck1030 FIND v(dout0_7) AT=1040.05n

.meas tran vdout0_8ck1030 FIND v(dout0_8) AT=1040.05n

.meas tran vdout0_9ck1030 FIND v(dout0_9) AT=1040.05n

.meas tran vdout0_10ck1030 FIND v(dout0_10) AT=1040.05n

.meas tran vdout0_11ck1030 FIND v(dout0_11) AT=1040.05n

.meas tran vdout0_12ck1030 FIND v(dout0_12) AT=1040.05n

.meas tran vdout0_13ck1030 FIND v(dout0_13) AT=1040.05n

.meas tran vdout0_14ck1030 FIND v(dout0_14) AT=1040.05n

.meas tran vdout0_15ck1030 FIND v(dout0_15) AT=1040.05n

.meas tran vdout0_16ck1030 FIND v(dout0_16) AT=1040.05n

.meas tran vdout0_17ck1030 FIND v(dout0_17) AT=1040.05n

.meas tran vdout0_18ck1030 FIND v(dout0_18) AT=1040.05n

.meas tran vdout0_19ck1030 FIND v(dout0_19) AT=1040.05n

.meas tran vdout0_20ck1030 FIND v(dout0_20) AT=1040.05n

.meas tran vdout0_21ck1030 FIND v(dout0_21) AT=1040.05n

.meas tran vdout0_22ck1030 FIND v(dout0_22) AT=1040.05n

.meas tran vdout0_23ck1030 FIND v(dout0_23) AT=1040.05n

.meas tran vdout0_24ck1030 FIND v(dout0_24) AT=1040.05n

.meas tran vdout0_25ck1030 FIND v(dout0_25) AT=1040.05n

.meas tran vdout0_26ck1030 FIND v(dout0_26) AT=1040.05n

.meas tran vdout0_27ck1030 FIND v(dout0_27) AT=1040.05n

.meas tran vdout0_28ck1030 FIND v(dout0_28) AT=1040.05n

.meas tran vdout0_29ck1030 FIND v(dout0_29) AT=1040.05n

.meas tran vdout0_30ck1030 FIND v(dout0_30) AT=1040.05n

.meas tran vdout0_31ck1030 FIND v(dout0_31) AT=1040.05n

.meas tran vdout0_0ck1040 FIND v(dout0_0) AT=1050.05n

.meas tran vdout0_1ck1040 FIND v(dout0_1) AT=1050.05n

.meas tran vdout0_2ck1040 FIND v(dout0_2) AT=1050.05n

.meas tran vdout0_3ck1040 FIND v(dout0_3) AT=1050.05n

.meas tran vdout0_4ck1040 FIND v(dout0_4) AT=1050.05n

.meas tran vdout0_5ck1040 FIND v(dout0_5) AT=1050.05n

.meas tran vdout0_6ck1040 FIND v(dout0_6) AT=1050.05n

.meas tran vdout0_7ck1040 FIND v(dout0_7) AT=1050.05n

.meas tran vdout0_8ck1040 FIND v(dout0_8) AT=1050.05n

.meas tran vdout0_9ck1040 FIND v(dout0_9) AT=1050.05n

.meas tran vdout0_10ck1040 FIND v(dout0_10) AT=1050.05n

.meas tran vdout0_11ck1040 FIND v(dout0_11) AT=1050.05n

.meas tran vdout0_12ck1040 FIND v(dout0_12) AT=1050.05n

.meas tran vdout0_13ck1040 FIND v(dout0_13) AT=1050.05n

.meas tran vdout0_14ck1040 FIND v(dout0_14) AT=1050.05n

.meas tran vdout0_15ck1040 FIND v(dout0_15) AT=1050.05n

.meas tran vdout0_16ck1040 FIND v(dout0_16) AT=1050.05n

.meas tran vdout0_17ck1040 FIND v(dout0_17) AT=1050.05n

.meas tran vdout0_18ck1040 FIND v(dout0_18) AT=1050.05n

.meas tran vdout0_19ck1040 FIND v(dout0_19) AT=1050.05n

.meas tran vdout0_20ck1040 FIND v(dout0_20) AT=1050.05n

.meas tran vdout0_21ck1040 FIND v(dout0_21) AT=1050.05n

.meas tran vdout0_22ck1040 FIND v(dout0_22) AT=1050.05n

.meas tran vdout0_23ck1040 FIND v(dout0_23) AT=1050.05n

.meas tran vdout0_24ck1040 FIND v(dout0_24) AT=1050.05n

.meas tran vdout0_25ck1040 FIND v(dout0_25) AT=1050.05n

.meas tran vdout0_26ck1040 FIND v(dout0_26) AT=1050.05n

.meas tran vdout0_27ck1040 FIND v(dout0_27) AT=1050.05n

.meas tran vdout0_28ck1040 FIND v(dout0_28) AT=1050.05n

.meas tran vdout0_29ck1040 FIND v(dout0_29) AT=1050.05n

.meas tran vdout0_30ck1040 FIND v(dout0_30) AT=1050.05n

.meas tran vdout0_31ck1040 FIND v(dout0_31) AT=1050.05n

.meas tran vdout0_0ck1050 FIND v(dout0_0) AT=1060.05n

.meas tran vdout0_1ck1050 FIND v(dout0_1) AT=1060.05n

.meas tran vdout0_2ck1050 FIND v(dout0_2) AT=1060.05n

.meas tran vdout0_3ck1050 FIND v(dout0_3) AT=1060.05n

.meas tran vdout0_4ck1050 FIND v(dout0_4) AT=1060.05n

.meas tran vdout0_5ck1050 FIND v(dout0_5) AT=1060.05n

.meas tran vdout0_6ck1050 FIND v(dout0_6) AT=1060.05n

.meas tran vdout0_7ck1050 FIND v(dout0_7) AT=1060.05n

.meas tran vdout0_8ck1050 FIND v(dout0_8) AT=1060.05n

.meas tran vdout0_9ck1050 FIND v(dout0_9) AT=1060.05n

.meas tran vdout0_10ck1050 FIND v(dout0_10) AT=1060.05n

.meas tran vdout0_11ck1050 FIND v(dout0_11) AT=1060.05n

.meas tran vdout0_12ck1050 FIND v(dout0_12) AT=1060.05n

.meas tran vdout0_13ck1050 FIND v(dout0_13) AT=1060.05n

.meas tran vdout0_14ck1050 FIND v(dout0_14) AT=1060.05n

.meas tran vdout0_15ck1050 FIND v(dout0_15) AT=1060.05n

.meas tran vdout0_16ck1050 FIND v(dout0_16) AT=1060.05n

.meas tran vdout0_17ck1050 FIND v(dout0_17) AT=1060.05n

.meas tran vdout0_18ck1050 FIND v(dout0_18) AT=1060.05n

.meas tran vdout0_19ck1050 FIND v(dout0_19) AT=1060.05n

.meas tran vdout0_20ck1050 FIND v(dout0_20) AT=1060.05n

.meas tran vdout0_21ck1050 FIND v(dout0_21) AT=1060.05n

.meas tran vdout0_22ck1050 FIND v(dout0_22) AT=1060.05n

.meas tran vdout0_23ck1050 FIND v(dout0_23) AT=1060.05n

.meas tran vdout0_24ck1050 FIND v(dout0_24) AT=1060.05n

.meas tran vdout0_25ck1050 FIND v(dout0_25) AT=1060.05n

.meas tran vdout0_26ck1050 FIND v(dout0_26) AT=1060.05n

.meas tran vdout0_27ck1050 FIND v(dout0_27) AT=1060.05n

.meas tran vdout0_28ck1050 FIND v(dout0_28) AT=1060.05n

.meas tran vdout0_29ck1050 FIND v(dout0_29) AT=1060.05n

.meas tran vdout0_30ck1050 FIND v(dout0_30) AT=1060.05n

.meas tran vdout0_31ck1050 FIND v(dout0_31) AT=1060.05n

.meas tran vdout0_0ck1060 FIND v(dout0_0) AT=1070.05n

.meas tran vdout0_1ck1060 FIND v(dout0_1) AT=1070.05n

.meas tran vdout0_2ck1060 FIND v(dout0_2) AT=1070.05n

.meas tran vdout0_3ck1060 FIND v(dout0_3) AT=1070.05n

.meas tran vdout0_4ck1060 FIND v(dout0_4) AT=1070.05n

.meas tran vdout0_5ck1060 FIND v(dout0_5) AT=1070.05n

.meas tran vdout0_6ck1060 FIND v(dout0_6) AT=1070.05n

.meas tran vdout0_7ck1060 FIND v(dout0_7) AT=1070.05n

.meas tran vdout0_8ck1060 FIND v(dout0_8) AT=1070.05n

.meas tran vdout0_9ck1060 FIND v(dout0_9) AT=1070.05n

.meas tran vdout0_10ck1060 FIND v(dout0_10) AT=1070.05n

.meas tran vdout0_11ck1060 FIND v(dout0_11) AT=1070.05n

.meas tran vdout0_12ck1060 FIND v(dout0_12) AT=1070.05n

.meas tran vdout0_13ck1060 FIND v(dout0_13) AT=1070.05n

.meas tran vdout0_14ck1060 FIND v(dout0_14) AT=1070.05n

.meas tran vdout0_15ck1060 FIND v(dout0_15) AT=1070.05n

.meas tran vdout0_16ck1060 FIND v(dout0_16) AT=1070.05n

.meas tran vdout0_17ck1060 FIND v(dout0_17) AT=1070.05n

.meas tran vdout0_18ck1060 FIND v(dout0_18) AT=1070.05n

.meas tran vdout0_19ck1060 FIND v(dout0_19) AT=1070.05n

.meas tran vdout0_20ck1060 FIND v(dout0_20) AT=1070.05n

.meas tran vdout0_21ck1060 FIND v(dout0_21) AT=1070.05n

.meas tran vdout0_22ck1060 FIND v(dout0_22) AT=1070.05n

.meas tran vdout0_23ck1060 FIND v(dout0_23) AT=1070.05n

.meas tran vdout0_24ck1060 FIND v(dout0_24) AT=1070.05n

.meas tran vdout0_25ck1060 FIND v(dout0_25) AT=1070.05n

.meas tran vdout0_26ck1060 FIND v(dout0_26) AT=1070.05n

.meas tran vdout0_27ck1060 FIND v(dout0_27) AT=1070.05n

.meas tran vdout0_28ck1060 FIND v(dout0_28) AT=1070.05n

.meas tran vdout0_29ck1060 FIND v(dout0_29) AT=1070.05n

.meas tran vdout0_30ck1060 FIND v(dout0_30) AT=1070.05n

.meas tran vdout0_31ck1060 FIND v(dout0_31) AT=1070.05n

.meas tran vdout0_0ck1100 FIND v(dout0_0) AT=1110.05n

.meas tran vdout0_1ck1100 FIND v(dout0_1) AT=1110.05n

.meas tran vdout0_2ck1100 FIND v(dout0_2) AT=1110.05n

.meas tran vdout0_3ck1100 FIND v(dout0_3) AT=1110.05n

.meas tran vdout0_4ck1100 FIND v(dout0_4) AT=1110.05n

.meas tran vdout0_5ck1100 FIND v(dout0_5) AT=1110.05n

.meas tran vdout0_6ck1100 FIND v(dout0_6) AT=1110.05n

.meas tran vdout0_7ck1100 FIND v(dout0_7) AT=1110.05n

.meas tran vdout0_8ck1100 FIND v(dout0_8) AT=1110.05n

.meas tran vdout0_9ck1100 FIND v(dout0_9) AT=1110.05n

.meas tran vdout0_10ck1100 FIND v(dout0_10) AT=1110.05n

.meas tran vdout0_11ck1100 FIND v(dout0_11) AT=1110.05n

.meas tran vdout0_12ck1100 FIND v(dout0_12) AT=1110.05n

.meas tran vdout0_13ck1100 FIND v(dout0_13) AT=1110.05n

.meas tran vdout0_14ck1100 FIND v(dout0_14) AT=1110.05n

.meas tran vdout0_15ck1100 FIND v(dout0_15) AT=1110.05n

.meas tran vdout0_16ck1100 FIND v(dout0_16) AT=1110.05n

.meas tran vdout0_17ck1100 FIND v(dout0_17) AT=1110.05n

.meas tran vdout0_18ck1100 FIND v(dout0_18) AT=1110.05n

.meas tran vdout0_19ck1100 FIND v(dout0_19) AT=1110.05n

.meas tran vdout0_20ck1100 FIND v(dout0_20) AT=1110.05n

.meas tran vdout0_21ck1100 FIND v(dout0_21) AT=1110.05n

.meas tran vdout0_22ck1100 FIND v(dout0_22) AT=1110.05n

.meas tran vdout0_23ck1100 FIND v(dout0_23) AT=1110.05n

.meas tran vdout0_24ck1100 FIND v(dout0_24) AT=1110.05n

.meas tran vdout0_25ck1100 FIND v(dout0_25) AT=1110.05n

.meas tran vdout0_26ck1100 FIND v(dout0_26) AT=1110.05n

.meas tran vdout0_27ck1100 FIND v(dout0_27) AT=1110.05n

.meas tran vdout0_28ck1100 FIND v(dout0_28) AT=1110.05n

.meas tran vdout0_29ck1100 FIND v(dout0_29) AT=1110.05n

.meas tran vdout0_30ck1100 FIND v(dout0_30) AT=1110.05n

.meas tran vdout0_31ck1100 FIND v(dout0_31) AT=1110.05n

.meas tran vdout0_0ck1140 FIND v(dout0_0) AT=1150.05n

.meas tran vdout0_1ck1140 FIND v(dout0_1) AT=1150.05n

.meas tran vdout0_2ck1140 FIND v(dout0_2) AT=1150.05n

.meas tran vdout0_3ck1140 FIND v(dout0_3) AT=1150.05n

.meas tran vdout0_4ck1140 FIND v(dout0_4) AT=1150.05n

.meas tran vdout0_5ck1140 FIND v(dout0_5) AT=1150.05n

.meas tran vdout0_6ck1140 FIND v(dout0_6) AT=1150.05n

.meas tran vdout0_7ck1140 FIND v(dout0_7) AT=1150.05n

.meas tran vdout0_8ck1140 FIND v(dout0_8) AT=1150.05n

.meas tran vdout0_9ck1140 FIND v(dout0_9) AT=1150.05n

.meas tran vdout0_10ck1140 FIND v(dout0_10) AT=1150.05n

.meas tran vdout0_11ck1140 FIND v(dout0_11) AT=1150.05n

.meas tran vdout0_12ck1140 FIND v(dout0_12) AT=1150.05n

.meas tran vdout0_13ck1140 FIND v(dout0_13) AT=1150.05n

.meas tran vdout0_14ck1140 FIND v(dout0_14) AT=1150.05n

.meas tran vdout0_15ck1140 FIND v(dout0_15) AT=1150.05n

.meas tran vdout0_16ck1140 FIND v(dout0_16) AT=1150.05n

.meas tran vdout0_17ck1140 FIND v(dout0_17) AT=1150.05n

.meas tran vdout0_18ck1140 FIND v(dout0_18) AT=1150.05n

.meas tran vdout0_19ck1140 FIND v(dout0_19) AT=1150.05n

.meas tran vdout0_20ck1140 FIND v(dout0_20) AT=1150.05n

.meas tran vdout0_21ck1140 FIND v(dout0_21) AT=1150.05n

.meas tran vdout0_22ck1140 FIND v(dout0_22) AT=1150.05n

.meas tran vdout0_23ck1140 FIND v(dout0_23) AT=1150.05n

.meas tran vdout0_24ck1140 FIND v(dout0_24) AT=1150.05n

.meas tran vdout0_25ck1140 FIND v(dout0_25) AT=1150.05n

.meas tran vdout0_26ck1140 FIND v(dout0_26) AT=1150.05n

.meas tran vdout0_27ck1140 FIND v(dout0_27) AT=1150.05n

.meas tran vdout0_28ck1140 FIND v(dout0_28) AT=1150.05n

.meas tran vdout0_29ck1140 FIND v(dout0_29) AT=1150.05n

.meas tran vdout0_30ck1140 FIND v(dout0_30) AT=1150.05n

.meas tran vdout0_31ck1140 FIND v(dout0_31) AT=1150.05n

.meas tran vdout0_0ck1180 FIND v(dout0_0) AT=1190.05n

.meas tran vdout0_1ck1180 FIND v(dout0_1) AT=1190.05n

.meas tran vdout0_2ck1180 FIND v(dout0_2) AT=1190.05n

.meas tran vdout0_3ck1180 FIND v(dout0_3) AT=1190.05n

.meas tran vdout0_4ck1180 FIND v(dout0_4) AT=1190.05n

.meas tran vdout0_5ck1180 FIND v(dout0_5) AT=1190.05n

.meas tran vdout0_6ck1180 FIND v(dout0_6) AT=1190.05n

.meas tran vdout0_7ck1180 FIND v(dout0_7) AT=1190.05n

.meas tran vdout0_8ck1180 FIND v(dout0_8) AT=1190.05n

.meas tran vdout0_9ck1180 FIND v(dout0_9) AT=1190.05n

.meas tran vdout0_10ck1180 FIND v(dout0_10) AT=1190.05n

.meas tran vdout0_11ck1180 FIND v(dout0_11) AT=1190.05n

.meas tran vdout0_12ck1180 FIND v(dout0_12) AT=1190.05n

.meas tran vdout0_13ck1180 FIND v(dout0_13) AT=1190.05n

.meas tran vdout0_14ck1180 FIND v(dout0_14) AT=1190.05n

.meas tran vdout0_15ck1180 FIND v(dout0_15) AT=1190.05n

.meas tran vdout0_16ck1180 FIND v(dout0_16) AT=1190.05n

.meas tran vdout0_17ck1180 FIND v(dout0_17) AT=1190.05n

.meas tran vdout0_18ck1180 FIND v(dout0_18) AT=1190.05n

.meas tran vdout0_19ck1180 FIND v(dout0_19) AT=1190.05n

.meas tran vdout0_20ck1180 FIND v(dout0_20) AT=1190.05n

.meas tran vdout0_21ck1180 FIND v(dout0_21) AT=1190.05n

.meas tran vdout0_22ck1180 FIND v(dout0_22) AT=1190.05n

.meas tran vdout0_23ck1180 FIND v(dout0_23) AT=1190.05n

.meas tran vdout0_24ck1180 FIND v(dout0_24) AT=1190.05n

.meas tran vdout0_25ck1180 FIND v(dout0_25) AT=1190.05n

.meas tran vdout0_26ck1180 FIND v(dout0_26) AT=1190.05n

.meas tran vdout0_27ck1180 FIND v(dout0_27) AT=1190.05n

.meas tran vdout0_28ck1180 FIND v(dout0_28) AT=1190.05n

.meas tran vdout0_29ck1180 FIND v(dout0_29) AT=1190.05n

.meas tran vdout0_30ck1180 FIND v(dout0_30) AT=1190.05n

.meas tran vdout0_31ck1180 FIND v(dout0_31) AT=1190.05n

.meas tran vdout0_0ck1240 FIND v(dout0_0) AT=1250.05n

.meas tran vdout0_1ck1240 FIND v(dout0_1) AT=1250.05n

.meas tran vdout0_2ck1240 FIND v(dout0_2) AT=1250.05n

.meas tran vdout0_3ck1240 FIND v(dout0_3) AT=1250.05n

.meas tran vdout0_4ck1240 FIND v(dout0_4) AT=1250.05n

.meas tran vdout0_5ck1240 FIND v(dout0_5) AT=1250.05n

.meas tran vdout0_6ck1240 FIND v(dout0_6) AT=1250.05n

.meas tran vdout0_7ck1240 FIND v(dout0_7) AT=1250.05n

.meas tran vdout0_8ck1240 FIND v(dout0_8) AT=1250.05n

.meas tran vdout0_9ck1240 FIND v(dout0_9) AT=1250.05n

.meas tran vdout0_10ck1240 FIND v(dout0_10) AT=1250.05n

.meas tran vdout0_11ck1240 FIND v(dout0_11) AT=1250.05n

.meas tran vdout0_12ck1240 FIND v(dout0_12) AT=1250.05n

.meas tran vdout0_13ck1240 FIND v(dout0_13) AT=1250.05n

.meas tran vdout0_14ck1240 FIND v(dout0_14) AT=1250.05n

.meas tran vdout0_15ck1240 FIND v(dout0_15) AT=1250.05n

.meas tran vdout0_16ck1240 FIND v(dout0_16) AT=1250.05n

.meas tran vdout0_17ck1240 FIND v(dout0_17) AT=1250.05n

.meas tran vdout0_18ck1240 FIND v(dout0_18) AT=1250.05n

.meas tran vdout0_19ck1240 FIND v(dout0_19) AT=1250.05n

.meas tran vdout0_20ck1240 FIND v(dout0_20) AT=1250.05n

.meas tran vdout0_21ck1240 FIND v(dout0_21) AT=1250.05n

.meas tran vdout0_22ck1240 FIND v(dout0_22) AT=1250.05n

.meas tran vdout0_23ck1240 FIND v(dout0_23) AT=1250.05n

.meas tran vdout0_24ck1240 FIND v(dout0_24) AT=1250.05n

.meas tran vdout0_25ck1240 FIND v(dout0_25) AT=1250.05n

.meas tran vdout0_26ck1240 FIND v(dout0_26) AT=1250.05n

.meas tran vdout0_27ck1240 FIND v(dout0_27) AT=1250.05n

.meas tran vdout0_28ck1240 FIND v(dout0_28) AT=1250.05n

.meas tran vdout0_29ck1240 FIND v(dout0_29) AT=1250.05n

.meas tran vdout0_30ck1240 FIND v(dout0_30) AT=1250.05n

.meas tran vdout0_31ck1240 FIND v(dout0_31) AT=1250.05n

.meas tran vdout0_0ck1250 FIND v(dout0_0) AT=1260.05n

.meas tran vdout0_1ck1250 FIND v(dout0_1) AT=1260.05n

.meas tran vdout0_2ck1250 FIND v(dout0_2) AT=1260.05n

.meas tran vdout0_3ck1250 FIND v(dout0_3) AT=1260.05n

.meas tran vdout0_4ck1250 FIND v(dout0_4) AT=1260.05n

.meas tran vdout0_5ck1250 FIND v(dout0_5) AT=1260.05n

.meas tran vdout0_6ck1250 FIND v(dout0_6) AT=1260.05n

.meas tran vdout0_7ck1250 FIND v(dout0_7) AT=1260.05n

.meas tran vdout0_8ck1250 FIND v(dout0_8) AT=1260.05n

.meas tran vdout0_9ck1250 FIND v(dout0_9) AT=1260.05n

.meas tran vdout0_10ck1250 FIND v(dout0_10) AT=1260.05n

.meas tran vdout0_11ck1250 FIND v(dout0_11) AT=1260.05n

.meas tran vdout0_12ck1250 FIND v(dout0_12) AT=1260.05n

.meas tran vdout0_13ck1250 FIND v(dout0_13) AT=1260.05n

.meas tran vdout0_14ck1250 FIND v(dout0_14) AT=1260.05n

.meas tran vdout0_15ck1250 FIND v(dout0_15) AT=1260.05n

.meas tran vdout0_16ck1250 FIND v(dout0_16) AT=1260.05n

.meas tran vdout0_17ck1250 FIND v(dout0_17) AT=1260.05n

.meas tran vdout0_18ck1250 FIND v(dout0_18) AT=1260.05n

.meas tran vdout0_19ck1250 FIND v(dout0_19) AT=1260.05n

.meas tran vdout0_20ck1250 FIND v(dout0_20) AT=1260.05n

.meas tran vdout0_21ck1250 FIND v(dout0_21) AT=1260.05n

.meas tran vdout0_22ck1250 FIND v(dout0_22) AT=1260.05n

.meas tran vdout0_23ck1250 FIND v(dout0_23) AT=1260.05n

.meas tran vdout0_24ck1250 FIND v(dout0_24) AT=1260.05n

.meas tran vdout0_25ck1250 FIND v(dout0_25) AT=1260.05n

.meas tran vdout0_26ck1250 FIND v(dout0_26) AT=1260.05n

.meas tran vdout0_27ck1250 FIND v(dout0_27) AT=1260.05n

.meas tran vdout0_28ck1250 FIND v(dout0_28) AT=1260.05n

.meas tran vdout0_29ck1250 FIND v(dout0_29) AT=1260.05n

.meas tran vdout0_30ck1250 FIND v(dout0_30) AT=1260.05n

.meas tran vdout0_31ck1250 FIND v(dout0_31) AT=1260.05n

.meas tran vdout0_0ck1260 FIND v(dout0_0) AT=1270.05n

.meas tran vdout0_1ck1260 FIND v(dout0_1) AT=1270.05n

.meas tran vdout0_2ck1260 FIND v(dout0_2) AT=1270.05n

.meas tran vdout0_3ck1260 FIND v(dout0_3) AT=1270.05n

.meas tran vdout0_4ck1260 FIND v(dout0_4) AT=1270.05n

.meas tran vdout0_5ck1260 FIND v(dout0_5) AT=1270.05n

.meas tran vdout0_6ck1260 FIND v(dout0_6) AT=1270.05n

.meas tran vdout0_7ck1260 FIND v(dout0_7) AT=1270.05n

.meas tran vdout0_8ck1260 FIND v(dout0_8) AT=1270.05n

.meas tran vdout0_9ck1260 FIND v(dout0_9) AT=1270.05n

.meas tran vdout0_10ck1260 FIND v(dout0_10) AT=1270.05n

.meas tran vdout0_11ck1260 FIND v(dout0_11) AT=1270.05n

.meas tran vdout0_12ck1260 FIND v(dout0_12) AT=1270.05n

.meas tran vdout0_13ck1260 FIND v(dout0_13) AT=1270.05n

.meas tran vdout0_14ck1260 FIND v(dout0_14) AT=1270.05n

.meas tran vdout0_15ck1260 FIND v(dout0_15) AT=1270.05n

.meas tran vdout0_16ck1260 FIND v(dout0_16) AT=1270.05n

.meas tran vdout0_17ck1260 FIND v(dout0_17) AT=1270.05n

.meas tran vdout0_18ck1260 FIND v(dout0_18) AT=1270.05n

.meas tran vdout0_19ck1260 FIND v(dout0_19) AT=1270.05n

.meas tran vdout0_20ck1260 FIND v(dout0_20) AT=1270.05n

.meas tran vdout0_21ck1260 FIND v(dout0_21) AT=1270.05n

.meas tran vdout0_22ck1260 FIND v(dout0_22) AT=1270.05n

.meas tran vdout0_23ck1260 FIND v(dout0_23) AT=1270.05n

.meas tran vdout0_24ck1260 FIND v(dout0_24) AT=1270.05n

.meas tran vdout0_25ck1260 FIND v(dout0_25) AT=1270.05n

.meas tran vdout0_26ck1260 FIND v(dout0_26) AT=1270.05n

.meas tran vdout0_27ck1260 FIND v(dout0_27) AT=1270.05n

.meas tran vdout0_28ck1260 FIND v(dout0_28) AT=1270.05n

.meas tran vdout0_29ck1260 FIND v(dout0_29) AT=1270.05n

.meas tran vdout0_30ck1260 FIND v(dout0_30) AT=1270.05n

.meas tran vdout0_31ck1260 FIND v(dout0_31) AT=1270.05n

.meas tran vdout0_0ck1290 FIND v(dout0_0) AT=1300.05n

.meas tran vdout0_1ck1290 FIND v(dout0_1) AT=1300.05n

.meas tran vdout0_2ck1290 FIND v(dout0_2) AT=1300.05n

.meas tran vdout0_3ck1290 FIND v(dout0_3) AT=1300.05n

.meas tran vdout0_4ck1290 FIND v(dout0_4) AT=1300.05n

.meas tran vdout0_5ck1290 FIND v(dout0_5) AT=1300.05n

.meas tran vdout0_6ck1290 FIND v(dout0_6) AT=1300.05n

.meas tran vdout0_7ck1290 FIND v(dout0_7) AT=1300.05n

.meas tran vdout0_8ck1290 FIND v(dout0_8) AT=1300.05n

.meas tran vdout0_9ck1290 FIND v(dout0_9) AT=1300.05n

.meas tran vdout0_10ck1290 FIND v(dout0_10) AT=1300.05n

.meas tran vdout0_11ck1290 FIND v(dout0_11) AT=1300.05n

.meas tran vdout0_12ck1290 FIND v(dout0_12) AT=1300.05n

.meas tran vdout0_13ck1290 FIND v(dout0_13) AT=1300.05n

.meas tran vdout0_14ck1290 FIND v(dout0_14) AT=1300.05n

.meas tran vdout0_15ck1290 FIND v(dout0_15) AT=1300.05n

.meas tran vdout0_16ck1290 FIND v(dout0_16) AT=1300.05n

.meas tran vdout0_17ck1290 FIND v(dout0_17) AT=1300.05n

.meas tran vdout0_18ck1290 FIND v(dout0_18) AT=1300.05n

.meas tran vdout0_19ck1290 FIND v(dout0_19) AT=1300.05n

.meas tran vdout0_20ck1290 FIND v(dout0_20) AT=1300.05n

.meas tran vdout0_21ck1290 FIND v(dout0_21) AT=1300.05n

.meas tran vdout0_22ck1290 FIND v(dout0_22) AT=1300.05n

.meas tran vdout0_23ck1290 FIND v(dout0_23) AT=1300.05n

.meas tran vdout0_24ck1290 FIND v(dout0_24) AT=1300.05n

.meas tran vdout0_25ck1290 FIND v(dout0_25) AT=1300.05n

.meas tran vdout0_26ck1290 FIND v(dout0_26) AT=1300.05n

.meas tran vdout0_27ck1290 FIND v(dout0_27) AT=1300.05n

.meas tran vdout0_28ck1290 FIND v(dout0_28) AT=1300.05n

.meas tran vdout0_29ck1290 FIND v(dout0_29) AT=1300.05n

.meas tran vdout0_30ck1290 FIND v(dout0_30) AT=1300.05n

.meas tran vdout0_31ck1290 FIND v(dout0_31) AT=1300.05n

.meas tran vdout0_0ck1350 FIND v(dout0_0) AT=1360.05n

.meas tran vdout0_1ck1350 FIND v(dout0_1) AT=1360.05n

.meas tran vdout0_2ck1350 FIND v(dout0_2) AT=1360.05n

.meas tran vdout0_3ck1350 FIND v(dout0_3) AT=1360.05n

.meas tran vdout0_4ck1350 FIND v(dout0_4) AT=1360.05n

.meas tran vdout0_5ck1350 FIND v(dout0_5) AT=1360.05n

.meas tran vdout0_6ck1350 FIND v(dout0_6) AT=1360.05n

.meas tran vdout0_7ck1350 FIND v(dout0_7) AT=1360.05n

.meas tran vdout0_8ck1350 FIND v(dout0_8) AT=1360.05n

.meas tran vdout0_9ck1350 FIND v(dout0_9) AT=1360.05n

.meas tran vdout0_10ck1350 FIND v(dout0_10) AT=1360.05n

.meas tran vdout0_11ck1350 FIND v(dout0_11) AT=1360.05n

.meas tran vdout0_12ck1350 FIND v(dout0_12) AT=1360.05n

.meas tran vdout0_13ck1350 FIND v(dout0_13) AT=1360.05n

.meas tran vdout0_14ck1350 FIND v(dout0_14) AT=1360.05n

.meas tran vdout0_15ck1350 FIND v(dout0_15) AT=1360.05n

.meas tran vdout0_16ck1350 FIND v(dout0_16) AT=1360.05n

.meas tran vdout0_17ck1350 FIND v(dout0_17) AT=1360.05n

.meas tran vdout0_18ck1350 FIND v(dout0_18) AT=1360.05n

.meas tran vdout0_19ck1350 FIND v(dout0_19) AT=1360.05n

.meas tran vdout0_20ck1350 FIND v(dout0_20) AT=1360.05n

.meas tran vdout0_21ck1350 FIND v(dout0_21) AT=1360.05n

.meas tran vdout0_22ck1350 FIND v(dout0_22) AT=1360.05n

.meas tran vdout0_23ck1350 FIND v(dout0_23) AT=1360.05n

.meas tran vdout0_24ck1350 FIND v(dout0_24) AT=1360.05n

.meas tran vdout0_25ck1350 FIND v(dout0_25) AT=1360.05n

.meas tran vdout0_26ck1350 FIND v(dout0_26) AT=1360.05n

.meas tran vdout0_27ck1350 FIND v(dout0_27) AT=1360.05n

.meas tran vdout0_28ck1350 FIND v(dout0_28) AT=1360.05n

.meas tran vdout0_29ck1350 FIND v(dout0_29) AT=1360.05n

.meas tran vdout0_30ck1350 FIND v(dout0_30) AT=1360.05n

.meas tran vdout0_31ck1350 FIND v(dout0_31) AT=1360.05n

.meas tran vdout0_0ck1370 FIND v(dout0_0) AT=1380.05n

.meas tran vdout0_1ck1370 FIND v(dout0_1) AT=1380.05n

.meas tran vdout0_2ck1370 FIND v(dout0_2) AT=1380.05n

.meas tran vdout0_3ck1370 FIND v(dout0_3) AT=1380.05n

.meas tran vdout0_4ck1370 FIND v(dout0_4) AT=1380.05n

.meas tran vdout0_5ck1370 FIND v(dout0_5) AT=1380.05n

.meas tran vdout0_6ck1370 FIND v(dout0_6) AT=1380.05n

.meas tran vdout0_7ck1370 FIND v(dout0_7) AT=1380.05n

.meas tran vdout0_8ck1370 FIND v(dout0_8) AT=1380.05n

.meas tran vdout0_9ck1370 FIND v(dout0_9) AT=1380.05n

.meas tran vdout0_10ck1370 FIND v(dout0_10) AT=1380.05n

.meas tran vdout0_11ck1370 FIND v(dout0_11) AT=1380.05n

.meas tran vdout0_12ck1370 FIND v(dout0_12) AT=1380.05n

.meas tran vdout0_13ck1370 FIND v(dout0_13) AT=1380.05n

.meas tran vdout0_14ck1370 FIND v(dout0_14) AT=1380.05n

.meas tran vdout0_15ck1370 FIND v(dout0_15) AT=1380.05n

.meas tran vdout0_16ck1370 FIND v(dout0_16) AT=1380.05n

.meas tran vdout0_17ck1370 FIND v(dout0_17) AT=1380.05n

.meas tran vdout0_18ck1370 FIND v(dout0_18) AT=1380.05n

.meas tran vdout0_19ck1370 FIND v(dout0_19) AT=1380.05n

.meas tran vdout0_20ck1370 FIND v(dout0_20) AT=1380.05n

.meas tran vdout0_21ck1370 FIND v(dout0_21) AT=1380.05n

.meas tran vdout0_22ck1370 FIND v(dout0_22) AT=1380.05n

.meas tran vdout0_23ck1370 FIND v(dout0_23) AT=1380.05n

.meas tran vdout0_24ck1370 FIND v(dout0_24) AT=1380.05n

.meas tran vdout0_25ck1370 FIND v(dout0_25) AT=1380.05n

.meas tran vdout0_26ck1370 FIND v(dout0_26) AT=1380.05n

.meas tran vdout0_27ck1370 FIND v(dout0_27) AT=1380.05n

.meas tran vdout0_28ck1370 FIND v(dout0_28) AT=1380.05n

.meas tran vdout0_29ck1370 FIND v(dout0_29) AT=1380.05n

.meas tran vdout0_30ck1370 FIND v(dout0_30) AT=1380.05n

.meas tran vdout0_31ck1370 FIND v(dout0_31) AT=1380.05n

.meas tran vdout0_0ck1400 FIND v(dout0_0) AT=1410.05n

.meas tran vdout0_1ck1400 FIND v(dout0_1) AT=1410.05n

.meas tran vdout0_2ck1400 FIND v(dout0_2) AT=1410.05n

.meas tran vdout0_3ck1400 FIND v(dout0_3) AT=1410.05n

.meas tran vdout0_4ck1400 FIND v(dout0_4) AT=1410.05n

.meas tran vdout0_5ck1400 FIND v(dout0_5) AT=1410.05n

.meas tran vdout0_6ck1400 FIND v(dout0_6) AT=1410.05n

.meas tran vdout0_7ck1400 FIND v(dout0_7) AT=1410.05n

.meas tran vdout0_8ck1400 FIND v(dout0_8) AT=1410.05n

.meas tran vdout0_9ck1400 FIND v(dout0_9) AT=1410.05n

.meas tran vdout0_10ck1400 FIND v(dout0_10) AT=1410.05n

.meas tran vdout0_11ck1400 FIND v(dout0_11) AT=1410.05n

.meas tran vdout0_12ck1400 FIND v(dout0_12) AT=1410.05n

.meas tran vdout0_13ck1400 FIND v(dout0_13) AT=1410.05n

.meas tran vdout0_14ck1400 FIND v(dout0_14) AT=1410.05n

.meas tran vdout0_15ck1400 FIND v(dout0_15) AT=1410.05n

.meas tran vdout0_16ck1400 FIND v(dout0_16) AT=1410.05n

.meas tran vdout0_17ck1400 FIND v(dout0_17) AT=1410.05n

.meas tran vdout0_18ck1400 FIND v(dout0_18) AT=1410.05n

.meas tran vdout0_19ck1400 FIND v(dout0_19) AT=1410.05n

.meas tran vdout0_20ck1400 FIND v(dout0_20) AT=1410.05n

.meas tran vdout0_21ck1400 FIND v(dout0_21) AT=1410.05n

.meas tran vdout0_22ck1400 FIND v(dout0_22) AT=1410.05n

.meas tran vdout0_23ck1400 FIND v(dout0_23) AT=1410.05n

.meas tran vdout0_24ck1400 FIND v(dout0_24) AT=1410.05n

.meas tran vdout0_25ck1400 FIND v(dout0_25) AT=1410.05n

.meas tran vdout0_26ck1400 FIND v(dout0_26) AT=1410.05n

.meas tran vdout0_27ck1400 FIND v(dout0_27) AT=1410.05n

.meas tran vdout0_28ck1400 FIND v(dout0_28) AT=1410.05n

.meas tran vdout0_29ck1400 FIND v(dout0_29) AT=1410.05n

.meas tran vdout0_30ck1400 FIND v(dout0_30) AT=1410.05n

.meas tran vdout0_31ck1400 FIND v(dout0_31) AT=1410.05n

.meas tran vdout0_0ck1450 FIND v(dout0_0) AT=1460.05n

.meas tran vdout0_1ck1450 FIND v(dout0_1) AT=1460.05n

.meas tran vdout0_2ck1450 FIND v(dout0_2) AT=1460.05n

.meas tran vdout0_3ck1450 FIND v(dout0_3) AT=1460.05n

.meas tran vdout0_4ck1450 FIND v(dout0_4) AT=1460.05n

.meas tran vdout0_5ck1450 FIND v(dout0_5) AT=1460.05n

.meas tran vdout0_6ck1450 FIND v(dout0_6) AT=1460.05n

.meas tran vdout0_7ck1450 FIND v(dout0_7) AT=1460.05n

.meas tran vdout0_8ck1450 FIND v(dout0_8) AT=1460.05n

.meas tran vdout0_9ck1450 FIND v(dout0_9) AT=1460.05n

.meas tran vdout0_10ck1450 FIND v(dout0_10) AT=1460.05n

.meas tran vdout0_11ck1450 FIND v(dout0_11) AT=1460.05n

.meas tran vdout0_12ck1450 FIND v(dout0_12) AT=1460.05n

.meas tran vdout0_13ck1450 FIND v(dout0_13) AT=1460.05n

.meas tran vdout0_14ck1450 FIND v(dout0_14) AT=1460.05n

.meas tran vdout0_15ck1450 FIND v(dout0_15) AT=1460.05n

.meas tran vdout0_16ck1450 FIND v(dout0_16) AT=1460.05n

.meas tran vdout0_17ck1450 FIND v(dout0_17) AT=1460.05n

.meas tran vdout0_18ck1450 FIND v(dout0_18) AT=1460.05n

.meas tran vdout0_19ck1450 FIND v(dout0_19) AT=1460.05n

.meas tran vdout0_20ck1450 FIND v(dout0_20) AT=1460.05n

.meas tran vdout0_21ck1450 FIND v(dout0_21) AT=1460.05n

.meas tran vdout0_22ck1450 FIND v(dout0_22) AT=1460.05n

.meas tran vdout0_23ck1450 FIND v(dout0_23) AT=1460.05n

.meas tran vdout0_24ck1450 FIND v(dout0_24) AT=1460.05n

.meas tran vdout0_25ck1450 FIND v(dout0_25) AT=1460.05n

.meas tran vdout0_26ck1450 FIND v(dout0_26) AT=1460.05n

.meas tran vdout0_27ck1450 FIND v(dout0_27) AT=1460.05n

.meas tran vdout0_28ck1450 FIND v(dout0_28) AT=1460.05n

.meas tran vdout0_29ck1450 FIND v(dout0_29) AT=1460.05n

.meas tran vdout0_30ck1450 FIND v(dout0_30) AT=1460.05n

.meas tran vdout0_31ck1450 FIND v(dout0_31) AT=1460.05n

.meas tran vdout0_0ck1460 FIND v(dout0_0) AT=1470.05n

.meas tran vdout0_1ck1460 FIND v(dout0_1) AT=1470.05n

.meas tran vdout0_2ck1460 FIND v(dout0_2) AT=1470.05n

.meas tran vdout0_3ck1460 FIND v(dout0_3) AT=1470.05n

.meas tran vdout0_4ck1460 FIND v(dout0_4) AT=1470.05n

.meas tran vdout0_5ck1460 FIND v(dout0_5) AT=1470.05n

.meas tran vdout0_6ck1460 FIND v(dout0_6) AT=1470.05n

.meas tran vdout0_7ck1460 FIND v(dout0_7) AT=1470.05n

.meas tran vdout0_8ck1460 FIND v(dout0_8) AT=1470.05n

.meas tran vdout0_9ck1460 FIND v(dout0_9) AT=1470.05n

.meas tran vdout0_10ck1460 FIND v(dout0_10) AT=1470.05n

.meas tran vdout0_11ck1460 FIND v(dout0_11) AT=1470.05n

.meas tran vdout0_12ck1460 FIND v(dout0_12) AT=1470.05n

.meas tran vdout0_13ck1460 FIND v(dout0_13) AT=1470.05n

.meas tran vdout0_14ck1460 FIND v(dout0_14) AT=1470.05n

.meas tran vdout0_15ck1460 FIND v(dout0_15) AT=1470.05n

.meas tran vdout0_16ck1460 FIND v(dout0_16) AT=1470.05n

.meas tran vdout0_17ck1460 FIND v(dout0_17) AT=1470.05n

.meas tran vdout0_18ck1460 FIND v(dout0_18) AT=1470.05n

.meas tran vdout0_19ck1460 FIND v(dout0_19) AT=1470.05n

.meas tran vdout0_20ck1460 FIND v(dout0_20) AT=1470.05n

.meas tran vdout0_21ck1460 FIND v(dout0_21) AT=1470.05n

.meas tran vdout0_22ck1460 FIND v(dout0_22) AT=1470.05n

.meas tran vdout0_23ck1460 FIND v(dout0_23) AT=1470.05n

.meas tran vdout0_24ck1460 FIND v(dout0_24) AT=1470.05n

.meas tran vdout0_25ck1460 FIND v(dout0_25) AT=1470.05n

.meas tran vdout0_26ck1460 FIND v(dout0_26) AT=1470.05n

.meas tran vdout0_27ck1460 FIND v(dout0_27) AT=1470.05n

.meas tran vdout0_28ck1460 FIND v(dout0_28) AT=1470.05n

.meas tran vdout0_29ck1460 FIND v(dout0_29) AT=1470.05n

.meas tran vdout0_30ck1460 FIND v(dout0_30) AT=1470.05n

.meas tran vdout0_31ck1460 FIND v(dout0_31) AT=1470.05n

.meas tran vdout0_0ck1470 FIND v(dout0_0) AT=1480.05n

.meas tran vdout0_1ck1470 FIND v(dout0_1) AT=1480.05n

.meas tran vdout0_2ck1470 FIND v(dout0_2) AT=1480.05n

.meas tran vdout0_3ck1470 FIND v(dout0_3) AT=1480.05n

.meas tran vdout0_4ck1470 FIND v(dout0_4) AT=1480.05n

.meas tran vdout0_5ck1470 FIND v(dout0_5) AT=1480.05n

.meas tran vdout0_6ck1470 FIND v(dout0_6) AT=1480.05n

.meas tran vdout0_7ck1470 FIND v(dout0_7) AT=1480.05n

.meas tran vdout0_8ck1470 FIND v(dout0_8) AT=1480.05n

.meas tran vdout0_9ck1470 FIND v(dout0_9) AT=1480.05n

.meas tran vdout0_10ck1470 FIND v(dout0_10) AT=1480.05n

.meas tran vdout0_11ck1470 FIND v(dout0_11) AT=1480.05n

.meas tran vdout0_12ck1470 FIND v(dout0_12) AT=1480.05n

.meas tran vdout0_13ck1470 FIND v(dout0_13) AT=1480.05n

.meas tran vdout0_14ck1470 FIND v(dout0_14) AT=1480.05n

.meas tran vdout0_15ck1470 FIND v(dout0_15) AT=1480.05n

.meas tran vdout0_16ck1470 FIND v(dout0_16) AT=1480.05n

.meas tran vdout0_17ck1470 FIND v(dout0_17) AT=1480.05n

.meas tran vdout0_18ck1470 FIND v(dout0_18) AT=1480.05n

.meas tran vdout0_19ck1470 FIND v(dout0_19) AT=1480.05n

.meas tran vdout0_20ck1470 FIND v(dout0_20) AT=1480.05n

.meas tran vdout0_21ck1470 FIND v(dout0_21) AT=1480.05n

.meas tran vdout0_22ck1470 FIND v(dout0_22) AT=1480.05n

.meas tran vdout0_23ck1470 FIND v(dout0_23) AT=1480.05n

.meas tran vdout0_24ck1470 FIND v(dout0_24) AT=1480.05n

.meas tran vdout0_25ck1470 FIND v(dout0_25) AT=1480.05n

.meas tran vdout0_26ck1470 FIND v(dout0_26) AT=1480.05n

.meas tran vdout0_27ck1470 FIND v(dout0_27) AT=1480.05n

.meas tran vdout0_28ck1470 FIND v(dout0_28) AT=1480.05n

.meas tran vdout0_29ck1470 FIND v(dout0_29) AT=1480.05n

.meas tran vdout0_30ck1470 FIND v(dout0_30) AT=1480.05n

.meas tran vdout0_31ck1470 FIND v(dout0_31) AT=1480.05n

.meas tran vdout0_0ck1490 FIND v(dout0_0) AT=1500.05n

.meas tran vdout0_1ck1490 FIND v(dout0_1) AT=1500.05n

.meas tran vdout0_2ck1490 FIND v(dout0_2) AT=1500.05n

.meas tran vdout0_3ck1490 FIND v(dout0_3) AT=1500.05n

.meas tran vdout0_4ck1490 FIND v(dout0_4) AT=1500.05n

.meas tran vdout0_5ck1490 FIND v(dout0_5) AT=1500.05n

.meas tran vdout0_6ck1490 FIND v(dout0_6) AT=1500.05n

.meas tran vdout0_7ck1490 FIND v(dout0_7) AT=1500.05n

.meas tran vdout0_8ck1490 FIND v(dout0_8) AT=1500.05n

.meas tran vdout0_9ck1490 FIND v(dout0_9) AT=1500.05n

.meas tran vdout0_10ck1490 FIND v(dout0_10) AT=1500.05n

.meas tran vdout0_11ck1490 FIND v(dout0_11) AT=1500.05n

.meas tran vdout0_12ck1490 FIND v(dout0_12) AT=1500.05n

.meas tran vdout0_13ck1490 FIND v(dout0_13) AT=1500.05n

.meas tran vdout0_14ck1490 FIND v(dout0_14) AT=1500.05n

.meas tran vdout0_15ck1490 FIND v(dout0_15) AT=1500.05n

.meas tran vdout0_16ck1490 FIND v(dout0_16) AT=1500.05n

.meas tran vdout0_17ck1490 FIND v(dout0_17) AT=1500.05n

.meas tran vdout0_18ck1490 FIND v(dout0_18) AT=1500.05n

.meas tran vdout0_19ck1490 FIND v(dout0_19) AT=1500.05n

.meas tran vdout0_20ck1490 FIND v(dout0_20) AT=1500.05n

.meas tran vdout0_21ck1490 FIND v(dout0_21) AT=1500.05n

.meas tran vdout0_22ck1490 FIND v(dout0_22) AT=1500.05n

.meas tran vdout0_23ck1490 FIND v(dout0_23) AT=1500.05n

.meas tran vdout0_24ck1490 FIND v(dout0_24) AT=1500.05n

.meas tran vdout0_25ck1490 FIND v(dout0_25) AT=1500.05n

.meas tran vdout0_26ck1490 FIND v(dout0_26) AT=1500.05n

.meas tran vdout0_27ck1490 FIND v(dout0_27) AT=1500.05n

.meas tran vdout0_28ck1490 FIND v(dout0_28) AT=1500.05n

.meas tran vdout0_29ck1490 FIND v(dout0_29) AT=1500.05n

.meas tran vdout0_30ck1490 FIND v(dout0_30) AT=1500.05n

.meas tran vdout0_31ck1490 FIND v(dout0_31) AT=1500.05n

.meas tran vdout0_0ck1580 FIND v(dout0_0) AT=1590.05n

.meas tran vdout0_1ck1580 FIND v(dout0_1) AT=1590.05n

.meas tran vdout0_2ck1580 FIND v(dout0_2) AT=1590.05n

.meas tran vdout0_3ck1580 FIND v(dout0_3) AT=1590.05n

.meas tran vdout0_4ck1580 FIND v(dout0_4) AT=1590.05n

.meas tran vdout0_5ck1580 FIND v(dout0_5) AT=1590.05n

.meas tran vdout0_6ck1580 FIND v(dout0_6) AT=1590.05n

.meas tran vdout0_7ck1580 FIND v(dout0_7) AT=1590.05n

.meas tran vdout0_8ck1580 FIND v(dout0_8) AT=1590.05n

.meas tran vdout0_9ck1580 FIND v(dout0_9) AT=1590.05n

.meas tran vdout0_10ck1580 FIND v(dout0_10) AT=1590.05n

.meas tran vdout0_11ck1580 FIND v(dout0_11) AT=1590.05n

.meas tran vdout0_12ck1580 FIND v(dout0_12) AT=1590.05n

.meas tran vdout0_13ck1580 FIND v(dout0_13) AT=1590.05n

.meas tran vdout0_14ck1580 FIND v(dout0_14) AT=1590.05n

.meas tran vdout0_15ck1580 FIND v(dout0_15) AT=1590.05n

.meas tran vdout0_16ck1580 FIND v(dout0_16) AT=1590.05n

.meas tran vdout0_17ck1580 FIND v(dout0_17) AT=1590.05n

.meas tran vdout0_18ck1580 FIND v(dout0_18) AT=1590.05n

.meas tran vdout0_19ck1580 FIND v(dout0_19) AT=1590.05n

.meas tran vdout0_20ck1580 FIND v(dout0_20) AT=1590.05n

.meas tran vdout0_21ck1580 FIND v(dout0_21) AT=1590.05n

.meas tran vdout0_22ck1580 FIND v(dout0_22) AT=1590.05n

.meas tran vdout0_23ck1580 FIND v(dout0_23) AT=1590.05n

.meas tran vdout0_24ck1580 FIND v(dout0_24) AT=1590.05n

.meas tran vdout0_25ck1580 FIND v(dout0_25) AT=1590.05n

.meas tran vdout0_26ck1580 FIND v(dout0_26) AT=1590.05n

.meas tran vdout0_27ck1580 FIND v(dout0_27) AT=1590.05n

.meas tran vdout0_28ck1580 FIND v(dout0_28) AT=1590.05n

.meas tran vdout0_29ck1580 FIND v(dout0_29) AT=1590.05n

.meas tran vdout0_30ck1580 FIND v(dout0_30) AT=1590.05n

.meas tran vdout0_31ck1580 FIND v(dout0_31) AT=1590.05n

.meas tran vdout0_0ck1600 FIND v(dout0_0) AT=1610.05n

.meas tran vdout0_1ck1600 FIND v(dout0_1) AT=1610.05n

.meas tran vdout0_2ck1600 FIND v(dout0_2) AT=1610.05n

.meas tran vdout0_3ck1600 FIND v(dout0_3) AT=1610.05n

.meas tran vdout0_4ck1600 FIND v(dout0_4) AT=1610.05n

.meas tran vdout0_5ck1600 FIND v(dout0_5) AT=1610.05n

.meas tran vdout0_6ck1600 FIND v(dout0_6) AT=1610.05n

.meas tran vdout0_7ck1600 FIND v(dout0_7) AT=1610.05n

.meas tran vdout0_8ck1600 FIND v(dout0_8) AT=1610.05n

.meas tran vdout0_9ck1600 FIND v(dout0_9) AT=1610.05n

.meas tran vdout0_10ck1600 FIND v(dout0_10) AT=1610.05n

.meas tran vdout0_11ck1600 FIND v(dout0_11) AT=1610.05n

.meas tran vdout0_12ck1600 FIND v(dout0_12) AT=1610.05n

.meas tran vdout0_13ck1600 FIND v(dout0_13) AT=1610.05n

.meas tran vdout0_14ck1600 FIND v(dout0_14) AT=1610.05n

.meas tran vdout0_15ck1600 FIND v(dout0_15) AT=1610.05n

.meas tran vdout0_16ck1600 FIND v(dout0_16) AT=1610.05n

.meas tran vdout0_17ck1600 FIND v(dout0_17) AT=1610.05n

.meas tran vdout0_18ck1600 FIND v(dout0_18) AT=1610.05n

.meas tran vdout0_19ck1600 FIND v(dout0_19) AT=1610.05n

.meas tran vdout0_20ck1600 FIND v(dout0_20) AT=1610.05n

.meas tran vdout0_21ck1600 FIND v(dout0_21) AT=1610.05n

.meas tran vdout0_22ck1600 FIND v(dout0_22) AT=1610.05n

.meas tran vdout0_23ck1600 FIND v(dout0_23) AT=1610.05n

.meas tran vdout0_24ck1600 FIND v(dout0_24) AT=1610.05n

.meas tran vdout0_25ck1600 FIND v(dout0_25) AT=1610.05n

.meas tran vdout0_26ck1600 FIND v(dout0_26) AT=1610.05n

.meas tran vdout0_27ck1600 FIND v(dout0_27) AT=1610.05n

.meas tran vdout0_28ck1600 FIND v(dout0_28) AT=1610.05n

.meas tran vdout0_29ck1600 FIND v(dout0_29) AT=1610.05n

.meas tran vdout0_30ck1600 FIND v(dout0_30) AT=1610.05n

.meas tran vdout0_31ck1600 FIND v(dout0_31) AT=1610.05n

.meas tran vdout0_0ck1620 FIND v(dout0_0) AT=1630.05n

.meas tran vdout0_1ck1620 FIND v(dout0_1) AT=1630.05n

.meas tran vdout0_2ck1620 FIND v(dout0_2) AT=1630.05n

.meas tran vdout0_3ck1620 FIND v(dout0_3) AT=1630.05n

.meas tran vdout0_4ck1620 FIND v(dout0_4) AT=1630.05n

.meas tran vdout0_5ck1620 FIND v(dout0_5) AT=1630.05n

.meas tran vdout0_6ck1620 FIND v(dout0_6) AT=1630.05n

.meas tran vdout0_7ck1620 FIND v(dout0_7) AT=1630.05n

.meas tran vdout0_8ck1620 FIND v(dout0_8) AT=1630.05n

.meas tran vdout0_9ck1620 FIND v(dout0_9) AT=1630.05n

.meas tran vdout0_10ck1620 FIND v(dout0_10) AT=1630.05n

.meas tran vdout0_11ck1620 FIND v(dout0_11) AT=1630.05n

.meas tran vdout0_12ck1620 FIND v(dout0_12) AT=1630.05n

.meas tran vdout0_13ck1620 FIND v(dout0_13) AT=1630.05n

.meas tran vdout0_14ck1620 FIND v(dout0_14) AT=1630.05n

.meas tran vdout0_15ck1620 FIND v(dout0_15) AT=1630.05n

.meas tran vdout0_16ck1620 FIND v(dout0_16) AT=1630.05n

.meas tran vdout0_17ck1620 FIND v(dout0_17) AT=1630.05n

.meas tran vdout0_18ck1620 FIND v(dout0_18) AT=1630.05n

.meas tran vdout0_19ck1620 FIND v(dout0_19) AT=1630.05n

.meas tran vdout0_20ck1620 FIND v(dout0_20) AT=1630.05n

.meas tran vdout0_21ck1620 FIND v(dout0_21) AT=1630.05n

.meas tran vdout0_22ck1620 FIND v(dout0_22) AT=1630.05n

.meas tran vdout0_23ck1620 FIND v(dout0_23) AT=1630.05n

.meas tran vdout0_24ck1620 FIND v(dout0_24) AT=1630.05n

.meas tran vdout0_25ck1620 FIND v(dout0_25) AT=1630.05n

.meas tran vdout0_26ck1620 FIND v(dout0_26) AT=1630.05n

.meas tran vdout0_27ck1620 FIND v(dout0_27) AT=1630.05n

.meas tran vdout0_28ck1620 FIND v(dout0_28) AT=1630.05n

.meas tran vdout0_29ck1620 FIND v(dout0_29) AT=1630.05n

.meas tran vdout0_30ck1620 FIND v(dout0_30) AT=1630.05n

.meas tran vdout0_31ck1620 FIND v(dout0_31) AT=1630.05n

.meas tran vdout0_0ck1630 FIND v(dout0_0) AT=1640.05n

.meas tran vdout0_1ck1630 FIND v(dout0_1) AT=1640.05n

.meas tran vdout0_2ck1630 FIND v(dout0_2) AT=1640.05n

.meas tran vdout0_3ck1630 FIND v(dout0_3) AT=1640.05n

.meas tran vdout0_4ck1630 FIND v(dout0_4) AT=1640.05n

.meas tran vdout0_5ck1630 FIND v(dout0_5) AT=1640.05n

.meas tran vdout0_6ck1630 FIND v(dout0_6) AT=1640.05n

.meas tran vdout0_7ck1630 FIND v(dout0_7) AT=1640.05n

.meas tran vdout0_8ck1630 FIND v(dout0_8) AT=1640.05n

.meas tran vdout0_9ck1630 FIND v(dout0_9) AT=1640.05n

.meas tran vdout0_10ck1630 FIND v(dout0_10) AT=1640.05n

.meas tran vdout0_11ck1630 FIND v(dout0_11) AT=1640.05n

.meas tran vdout0_12ck1630 FIND v(dout0_12) AT=1640.05n

.meas tran vdout0_13ck1630 FIND v(dout0_13) AT=1640.05n

.meas tran vdout0_14ck1630 FIND v(dout0_14) AT=1640.05n

.meas tran vdout0_15ck1630 FIND v(dout0_15) AT=1640.05n

.meas tran vdout0_16ck1630 FIND v(dout0_16) AT=1640.05n

.meas tran vdout0_17ck1630 FIND v(dout0_17) AT=1640.05n

.meas tran vdout0_18ck1630 FIND v(dout0_18) AT=1640.05n

.meas tran vdout0_19ck1630 FIND v(dout0_19) AT=1640.05n

.meas tran vdout0_20ck1630 FIND v(dout0_20) AT=1640.05n

.meas tran vdout0_21ck1630 FIND v(dout0_21) AT=1640.05n

.meas tran vdout0_22ck1630 FIND v(dout0_22) AT=1640.05n

.meas tran vdout0_23ck1630 FIND v(dout0_23) AT=1640.05n

.meas tran vdout0_24ck1630 FIND v(dout0_24) AT=1640.05n

.meas tran vdout0_25ck1630 FIND v(dout0_25) AT=1640.05n

.meas tran vdout0_26ck1630 FIND v(dout0_26) AT=1640.05n

.meas tran vdout0_27ck1630 FIND v(dout0_27) AT=1640.05n

.meas tran vdout0_28ck1630 FIND v(dout0_28) AT=1640.05n

.meas tran vdout0_29ck1630 FIND v(dout0_29) AT=1640.05n

.meas tran vdout0_30ck1630 FIND v(dout0_30) AT=1640.05n

.meas tran vdout0_31ck1630 FIND v(dout0_31) AT=1640.05n

.meas tran vdout0_0ck1660 FIND v(dout0_0) AT=1670.05n

.meas tran vdout0_1ck1660 FIND v(dout0_1) AT=1670.05n

.meas tran vdout0_2ck1660 FIND v(dout0_2) AT=1670.05n

.meas tran vdout0_3ck1660 FIND v(dout0_3) AT=1670.05n

.meas tran vdout0_4ck1660 FIND v(dout0_4) AT=1670.05n

.meas tran vdout0_5ck1660 FIND v(dout0_5) AT=1670.05n

.meas tran vdout0_6ck1660 FIND v(dout0_6) AT=1670.05n

.meas tran vdout0_7ck1660 FIND v(dout0_7) AT=1670.05n

.meas tran vdout0_8ck1660 FIND v(dout0_8) AT=1670.05n

.meas tran vdout0_9ck1660 FIND v(dout0_9) AT=1670.05n

.meas tran vdout0_10ck1660 FIND v(dout0_10) AT=1670.05n

.meas tran vdout0_11ck1660 FIND v(dout0_11) AT=1670.05n

.meas tran vdout0_12ck1660 FIND v(dout0_12) AT=1670.05n

.meas tran vdout0_13ck1660 FIND v(dout0_13) AT=1670.05n

.meas tran vdout0_14ck1660 FIND v(dout0_14) AT=1670.05n

.meas tran vdout0_15ck1660 FIND v(dout0_15) AT=1670.05n

.meas tran vdout0_16ck1660 FIND v(dout0_16) AT=1670.05n

.meas tran vdout0_17ck1660 FIND v(dout0_17) AT=1670.05n

.meas tran vdout0_18ck1660 FIND v(dout0_18) AT=1670.05n

.meas tran vdout0_19ck1660 FIND v(dout0_19) AT=1670.05n

.meas tran vdout0_20ck1660 FIND v(dout0_20) AT=1670.05n

.meas tran vdout0_21ck1660 FIND v(dout0_21) AT=1670.05n

.meas tran vdout0_22ck1660 FIND v(dout0_22) AT=1670.05n

.meas tran vdout0_23ck1660 FIND v(dout0_23) AT=1670.05n

.meas tran vdout0_24ck1660 FIND v(dout0_24) AT=1670.05n

.meas tran vdout0_25ck1660 FIND v(dout0_25) AT=1670.05n

.meas tran vdout0_26ck1660 FIND v(dout0_26) AT=1670.05n

.meas tran vdout0_27ck1660 FIND v(dout0_27) AT=1670.05n

.meas tran vdout0_28ck1660 FIND v(dout0_28) AT=1670.05n

.meas tran vdout0_29ck1660 FIND v(dout0_29) AT=1670.05n

.meas tran vdout0_30ck1660 FIND v(dout0_30) AT=1670.05n

.meas tran vdout0_31ck1660 FIND v(dout0_31) AT=1670.05n

.meas tran vdout0_0ck1670 FIND v(dout0_0) AT=1680.05n

.meas tran vdout0_1ck1670 FIND v(dout0_1) AT=1680.05n

.meas tran vdout0_2ck1670 FIND v(dout0_2) AT=1680.05n

.meas tran vdout0_3ck1670 FIND v(dout0_3) AT=1680.05n

.meas tran vdout0_4ck1670 FIND v(dout0_4) AT=1680.05n

.meas tran vdout0_5ck1670 FIND v(dout0_5) AT=1680.05n

.meas tran vdout0_6ck1670 FIND v(dout0_6) AT=1680.05n

.meas tran vdout0_7ck1670 FIND v(dout0_7) AT=1680.05n

.meas tran vdout0_8ck1670 FIND v(dout0_8) AT=1680.05n

.meas tran vdout0_9ck1670 FIND v(dout0_9) AT=1680.05n

.meas tran vdout0_10ck1670 FIND v(dout0_10) AT=1680.05n

.meas tran vdout0_11ck1670 FIND v(dout0_11) AT=1680.05n

.meas tran vdout0_12ck1670 FIND v(dout0_12) AT=1680.05n

.meas tran vdout0_13ck1670 FIND v(dout0_13) AT=1680.05n

.meas tran vdout0_14ck1670 FIND v(dout0_14) AT=1680.05n

.meas tran vdout0_15ck1670 FIND v(dout0_15) AT=1680.05n

.meas tran vdout0_16ck1670 FIND v(dout0_16) AT=1680.05n

.meas tran vdout0_17ck1670 FIND v(dout0_17) AT=1680.05n

.meas tran vdout0_18ck1670 FIND v(dout0_18) AT=1680.05n

.meas tran vdout0_19ck1670 FIND v(dout0_19) AT=1680.05n

.meas tran vdout0_20ck1670 FIND v(dout0_20) AT=1680.05n

.meas tran vdout0_21ck1670 FIND v(dout0_21) AT=1680.05n

.meas tran vdout0_22ck1670 FIND v(dout0_22) AT=1680.05n

.meas tran vdout0_23ck1670 FIND v(dout0_23) AT=1680.05n

.meas tran vdout0_24ck1670 FIND v(dout0_24) AT=1680.05n

.meas tran vdout0_25ck1670 FIND v(dout0_25) AT=1680.05n

.meas tran vdout0_26ck1670 FIND v(dout0_26) AT=1680.05n

.meas tran vdout0_27ck1670 FIND v(dout0_27) AT=1680.05n

.meas tran vdout0_28ck1670 FIND v(dout0_28) AT=1680.05n

.meas tran vdout0_29ck1670 FIND v(dout0_29) AT=1680.05n

.meas tran vdout0_30ck1670 FIND v(dout0_30) AT=1680.05n

.meas tran vdout0_31ck1670 FIND v(dout0_31) AT=1680.05n

.meas tran vdout0_0ck1680 FIND v(dout0_0) AT=1690.05n

.meas tran vdout0_1ck1680 FIND v(dout0_1) AT=1690.05n

.meas tran vdout0_2ck1680 FIND v(dout0_2) AT=1690.05n

.meas tran vdout0_3ck1680 FIND v(dout0_3) AT=1690.05n

.meas tran vdout0_4ck1680 FIND v(dout0_4) AT=1690.05n

.meas tran vdout0_5ck1680 FIND v(dout0_5) AT=1690.05n

.meas tran vdout0_6ck1680 FIND v(dout0_6) AT=1690.05n

.meas tran vdout0_7ck1680 FIND v(dout0_7) AT=1690.05n

.meas tran vdout0_8ck1680 FIND v(dout0_8) AT=1690.05n

.meas tran vdout0_9ck1680 FIND v(dout0_9) AT=1690.05n

.meas tran vdout0_10ck1680 FIND v(dout0_10) AT=1690.05n

.meas tran vdout0_11ck1680 FIND v(dout0_11) AT=1690.05n

.meas tran vdout0_12ck1680 FIND v(dout0_12) AT=1690.05n

.meas tran vdout0_13ck1680 FIND v(dout0_13) AT=1690.05n

.meas tran vdout0_14ck1680 FIND v(dout0_14) AT=1690.05n

.meas tran vdout0_15ck1680 FIND v(dout0_15) AT=1690.05n

.meas tran vdout0_16ck1680 FIND v(dout0_16) AT=1690.05n

.meas tran vdout0_17ck1680 FIND v(dout0_17) AT=1690.05n

.meas tran vdout0_18ck1680 FIND v(dout0_18) AT=1690.05n

.meas tran vdout0_19ck1680 FIND v(dout0_19) AT=1690.05n

.meas tran vdout0_20ck1680 FIND v(dout0_20) AT=1690.05n

.meas tran vdout0_21ck1680 FIND v(dout0_21) AT=1690.05n

.meas tran vdout0_22ck1680 FIND v(dout0_22) AT=1690.05n

.meas tran vdout0_23ck1680 FIND v(dout0_23) AT=1690.05n

.meas tran vdout0_24ck1680 FIND v(dout0_24) AT=1690.05n

.meas tran vdout0_25ck1680 FIND v(dout0_25) AT=1690.05n

.meas tran vdout0_26ck1680 FIND v(dout0_26) AT=1690.05n

.meas tran vdout0_27ck1680 FIND v(dout0_27) AT=1690.05n

.meas tran vdout0_28ck1680 FIND v(dout0_28) AT=1690.05n

.meas tran vdout0_29ck1680 FIND v(dout0_29) AT=1690.05n

.meas tran vdout0_30ck1680 FIND v(dout0_30) AT=1690.05n

.meas tran vdout0_31ck1680 FIND v(dout0_31) AT=1690.05n

.meas tran vdout0_0ck1690 FIND v(dout0_0) AT=1700.05n

.meas tran vdout0_1ck1690 FIND v(dout0_1) AT=1700.05n

.meas tran vdout0_2ck1690 FIND v(dout0_2) AT=1700.05n

.meas tran vdout0_3ck1690 FIND v(dout0_3) AT=1700.05n

.meas tran vdout0_4ck1690 FIND v(dout0_4) AT=1700.05n

.meas tran vdout0_5ck1690 FIND v(dout0_5) AT=1700.05n

.meas tran vdout0_6ck1690 FIND v(dout0_6) AT=1700.05n

.meas tran vdout0_7ck1690 FIND v(dout0_7) AT=1700.05n

.meas tran vdout0_8ck1690 FIND v(dout0_8) AT=1700.05n

.meas tran vdout0_9ck1690 FIND v(dout0_9) AT=1700.05n

.meas tran vdout0_10ck1690 FIND v(dout0_10) AT=1700.05n

.meas tran vdout0_11ck1690 FIND v(dout0_11) AT=1700.05n

.meas tran vdout0_12ck1690 FIND v(dout0_12) AT=1700.05n

.meas tran vdout0_13ck1690 FIND v(dout0_13) AT=1700.05n

.meas tran vdout0_14ck1690 FIND v(dout0_14) AT=1700.05n

.meas tran vdout0_15ck1690 FIND v(dout0_15) AT=1700.05n

.meas tran vdout0_16ck1690 FIND v(dout0_16) AT=1700.05n

.meas tran vdout0_17ck1690 FIND v(dout0_17) AT=1700.05n

.meas tran vdout0_18ck1690 FIND v(dout0_18) AT=1700.05n

.meas tran vdout0_19ck1690 FIND v(dout0_19) AT=1700.05n

.meas tran vdout0_20ck1690 FIND v(dout0_20) AT=1700.05n

.meas tran vdout0_21ck1690 FIND v(dout0_21) AT=1700.05n

.meas tran vdout0_22ck1690 FIND v(dout0_22) AT=1700.05n

.meas tran vdout0_23ck1690 FIND v(dout0_23) AT=1700.05n

.meas tran vdout0_24ck1690 FIND v(dout0_24) AT=1700.05n

.meas tran vdout0_25ck1690 FIND v(dout0_25) AT=1700.05n

.meas tran vdout0_26ck1690 FIND v(dout0_26) AT=1700.05n

.meas tran vdout0_27ck1690 FIND v(dout0_27) AT=1700.05n

.meas tran vdout0_28ck1690 FIND v(dout0_28) AT=1700.05n

.meas tran vdout0_29ck1690 FIND v(dout0_29) AT=1700.05n

.meas tran vdout0_30ck1690 FIND v(dout0_30) AT=1700.05n

.meas tran vdout0_31ck1690 FIND v(dout0_31) AT=1700.05n

.meas tran vdout0_0ck1710 FIND v(dout0_0) AT=1720.05n

.meas tran vdout0_1ck1710 FIND v(dout0_1) AT=1720.05n

.meas tran vdout0_2ck1710 FIND v(dout0_2) AT=1720.05n

.meas tran vdout0_3ck1710 FIND v(dout0_3) AT=1720.05n

.meas tran vdout0_4ck1710 FIND v(dout0_4) AT=1720.05n

.meas tran vdout0_5ck1710 FIND v(dout0_5) AT=1720.05n

.meas tran vdout0_6ck1710 FIND v(dout0_6) AT=1720.05n

.meas tran vdout0_7ck1710 FIND v(dout0_7) AT=1720.05n

.meas tran vdout0_8ck1710 FIND v(dout0_8) AT=1720.05n

.meas tran vdout0_9ck1710 FIND v(dout0_9) AT=1720.05n

.meas tran vdout0_10ck1710 FIND v(dout0_10) AT=1720.05n

.meas tran vdout0_11ck1710 FIND v(dout0_11) AT=1720.05n

.meas tran vdout0_12ck1710 FIND v(dout0_12) AT=1720.05n

.meas tran vdout0_13ck1710 FIND v(dout0_13) AT=1720.05n

.meas tran vdout0_14ck1710 FIND v(dout0_14) AT=1720.05n

.meas tran vdout0_15ck1710 FIND v(dout0_15) AT=1720.05n

.meas tran vdout0_16ck1710 FIND v(dout0_16) AT=1720.05n

.meas tran vdout0_17ck1710 FIND v(dout0_17) AT=1720.05n

.meas tran vdout0_18ck1710 FIND v(dout0_18) AT=1720.05n

.meas tran vdout0_19ck1710 FIND v(dout0_19) AT=1720.05n

.meas tran vdout0_20ck1710 FIND v(dout0_20) AT=1720.05n

.meas tran vdout0_21ck1710 FIND v(dout0_21) AT=1720.05n

.meas tran vdout0_22ck1710 FIND v(dout0_22) AT=1720.05n

.meas tran vdout0_23ck1710 FIND v(dout0_23) AT=1720.05n

.meas tran vdout0_24ck1710 FIND v(dout0_24) AT=1720.05n

.meas tran vdout0_25ck1710 FIND v(dout0_25) AT=1720.05n

.meas tran vdout0_26ck1710 FIND v(dout0_26) AT=1720.05n

.meas tran vdout0_27ck1710 FIND v(dout0_27) AT=1720.05n

.meas tran vdout0_28ck1710 FIND v(dout0_28) AT=1720.05n

.meas tran vdout0_29ck1710 FIND v(dout0_29) AT=1720.05n

.meas tran vdout0_30ck1710 FIND v(dout0_30) AT=1720.05n

.meas tran vdout0_31ck1710 FIND v(dout0_31) AT=1720.05n

.meas tran vdout0_0ck1740 FIND v(dout0_0) AT=1750.05n

.meas tran vdout0_1ck1740 FIND v(dout0_1) AT=1750.05n

.meas tran vdout0_2ck1740 FIND v(dout0_2) AT=1750.05n

.meas tran vdout0_3ck1740 FIND v(dout0_3) AT=1750.05n

.meas tran vdout0_4ck1740 FIND v(dout0_4) AT=1750.05n

.meas tran vdout0_5ck1740 FIND v(dout0_5) AT=1750.05n

.meas tran vdout0_6ck1740 FIND v(dout0_6) AT=1750.05n

.meas tran vdout0_7ck1740 FIND v(dout0_7) AT=1750.05n

.meas tran vdout0_8ck1740 FIND v(dout0_8) AT=1750.05n

.meas tran vdout0_9ck1740 FIND v(dout0_9) AT=1750.05n

.meas tran vdout0_10ck1740 FIND v(dout0_10) AT=1750.05n

.meas tran vdout0_11ck1740 FIND v(dout0_11) AT=1750.05n

.meas tran vdout0_12ck1740 FIND v(dout0_12) AT=1750.05n

.meas tran vdout0_13ck1740 FIND v(dout0_13) AT=1750.05n

.meas tran vdout0_14ck1740 FIND v(dout0_14) AT=1750.05n

.meas tran vdout0_15ck1740 FIND v(dout0_15) AT=1750.05n

.meas tran vdout0_16ck1740 FIND v(dout0_16) AT=1750.05n

.meas tran vdout0_17ck1740 FIND v(dout0_17) AT=1750.05n

.meas tran vdout0_18ck1740 FIND v(dout0_18) AT=1750.05n

.meas tran vdout0_19ck1740 FIND v(dout0_19) AT=1750.05n

.meas tran vdout0_20ck1740 FIND v(dout0_20) AT=1750.05n

.meas tran vdout0_21ck1740 FIND v(dout0_21) AT=1750.05n

.meas tran vdout0_22ck1740 FIND v(dout0_22) AT=1750.05n

.meas tran vdout0_23ck1740 FIND v(dout0_23) AT=1750.05n

.meas tran vdout0_24ck1740 FIND v(dout0_24) AT=1750.05n

.meas tran vdout0_25ck1740 FIND v(dout0_25) AT=1750.05n

.meas tran vdout0_26ck1740 FIND v(dout0_26) AT=1750.05n

.meas tran vdout0_27ck1740 FIND v(dout0_27) AT=1750.05n

.meas tran vdout0_28ck1740 FIND v(dout0_28) AT=1750.05n

.meas tran vdout0_29ck1740 FIND v(dout0_29) AT=1750.05n

.meas tran vdout0_30ck1740 FIND v(dout0_30) AT=1750.05n

.meas tran vdout0_31ck1740 FIND v(dout0_31) AT=1750.05n

.meas tran vdout0_0ck1820 FIND v(dout0_0) AT=1830.05n

.meas tran vdout0_1ck1820 FIND v(dout0_1) AT=1830.05n

.meas tran vdout0_2ck1820 FIND v(dout0_2) AT=1830.05n

.meas tran vdout0_3ck1820 FIND v(dout0_3) AT=1830.05n

.meas tran vdout0_4ck1820 FIND v(dout0_4) AT=1830.05n

.meas tran vdout0_5ck1820 FIND v(dout0_5) AT=1830.05n

.meas tran vdout0_6ck1820 FIND v(dout0_6) AT=1830.05n

.meas tran vdout0_7ck1820 FIND v(dout0_7) AT=1830.05n

.meas tran vdout0_8ck1820 FIND v(dout0_8) AT=1830.05n

.meas tran vdout0_9ck1820 FIND v(dout0_9) AT=1830.05n

.meas tran vdout0_10ck1820 FIND v(dout0_10) AT=1830.05n

.meas tran vdout0_11ck1820 FIND v(dout0_11) AT=1830.05n

.meas tran vdout0_12ck1820 FIND v(dout0_12) AT=1830.05n

.meas tran vdout0_13ck1820 FIND v(dout0_13) AT=1830.05n

.meas tran vdout0_14ck1820 FIND v(dout0_14) AT=1830.05n

.meas tran vdout0_15ck1820 FIND v(dout0_15) AT=1830.05n

.meas tran vdout0_16ck1820 FIND v(dout0_16) AT=1830.05n

.meas tran vdout0_17ck1820 FIND v(dout0_17) AT=1830.05n

.meas tran vdout0_18ck1820 FIND v(dout0_18) AT=1830.05n

.meas tran vdout0_19ck1820 FIND v(dout0_19) AT=1830.05n

.meas tran vdout0_20ck1820 FIND v(dout0_20) AT=1830.05n

.meas tran vdout0_21ck1820 FIND v(dout0_21) AT=1830.05n

.meas tran vdout0_22ck1820 FIND v(dout0_22) AT=1830.05n

.meas tran vdout0_23ck1820 FIND v(dout0_23) AT=1830.05n

.meas tran vdout0_24ck1820 FIND v(dout0_24) AT=1830.05n

.meas tran vdout0_25ck1820 FIND v(dout0_25) AT=1830.05n

.meas tran vdout0_26ck1820 FIND v(dout0_26) AT=1830.05n

.meas tran vdout0_27ck1820 FIND v(dout0_27) AT=1830.05n

.meas tran vdout0_28ck1820 FIND v(dout0_28) AT=1830.05n

.meas tran vdout0_29ck1820 FIND v(dout0_29) AT=1830.05n

.meas tran vdout0_30ck1820 FIND v(dout0_30) AT=1830.05n

.meas tran vdout0_31ck1820 FIND v(dout0_31) AT=1830.05n

.meas tran vdout0_0ck1830 FIND v(dout0_0) AT=1840.05n

.meas tran vdout0_1ck1830 FIND v(dout0_1) AT=1840.05n

.meas tran vdout0_2ck1830 FIND v(dout0_2) AT=1840.05n

.meas tran vdout0_3ck1830 FIND v(dout0_3) AT=1840.05n

.meas tran vdout0_4ck1830 FIND v(dout0_4) AT=1840.05n

.meas tran vdout0_5ck1830 FIND v(dout0_5) AT=1840.05n

.meas tran vdout0_6ck1830 FIND v(dout0_6) AT=1840.05n

.meas tran vdout0_7ck1830 FIND v(dout0_7) AT=1840.05n

.meas tran vdout0_8ck1830 FIND v(dout0_8) AT=1840.05n

.meas tran vdout0_9ck1830 FIND v(dout0_9) AT=1840.05n

.meas tran vdout0_10ck1830 FIND v(dout0_10) AT=1840.05n

.meas tran vdout0_11ck1830 FIND v(dout0_11) AT=1840.05n

.meas tran vdout0_12ck1830 FIND v(dout0_12) AT=1840.05n

.meas tran vdout0_13ck1830 FIND v(dout0_13) AT=1840.05n

.meas tran vdout0_14ck1830 FIND v(dout0_14) AT=1840.05n

.meas tran vdout0_15ck1830 FIND v(dout0_15) AT=1840.05n

.meas tran vdout0_16ck1830 FIND v(dout0_16) AT=1840.05n

.meas tran vdout0_17ck1830 FIND v(dout0_17) AT=1840.05n

.meas tran vdout0_18ck1830 FIND v(dout0_18) AT=1840.05n

.meas tran vdout0_19ck1830 FIND v(dout0_19) AT=1840.05n

.meas tran vdout0_20ck1830 FIND v(dout0_20) AT=1840.05n

.meas tran vdout0_21ck1830 FIND v(dout0_21) AT=1840.05n

.meas tran vdout0_22ck1830 FIND v(dout0_22) AT=1840.05n

.meas tran vdout0_23ck1830 FIND v(dout0_23) AT=1840.05n

.meas tran vdout0_24ck1830 FIND v(dout0_24) AT=1840.05n

.meas tran vdout0_25ck1830 FIND v(dout0_25) AT=1840.05n

.meas tran vdout0_26ck1830 FIND v(dout0_26) AT=1840.05n

.meas tran vdout0_27ck1830 FIND v(dout0_27) AT=1840.05n

.meas tran vdout0_28ck1830 FIND v(dout0_28) AT=1840.05n

.meas tran vdout0_29ck1830 FIND v(dout0_29) AT=1840.05n

.meas tran vdout0_30ck1830 FIND v(dout0_30) AT=1840.05n

.meas tran vdout0_31ck1830 FIND v(dout0_31) AT=1840.05n

.meas tran vdout0_0ck1870 FIND v(dout0_0) AT=1880.05n

.meas tran vdout0_1ck1870 FIND v(dout0_1) AT=1880.05n

.meas tran vdout0_2ck1870 FIND v(dout0_2) AT=1880.05n

.meas tran vdout0_3ck1870 FIND v(dout0_3) AT=1880.05n

.meas tran vdout0_4ck1870 FIND v(dout0_4) AT=1880.05n

.meas tran vdout0_5ck1870 FIND v(dout0_5) AT=1880.05n

.meas tran vdout0_6ck1870 FIND v(dout0_6) AT=1880.05n

.meas tran vdout0_7ck1870 FIND v(dout0_7) AT=1880.05n

.meas tran vdout0_8ck1870 FIND v(dout0_8) AT=1880.05n

.meas tran vdout0_9ck1870 FIND v(dout0_9) AT=1880.05n

.meas tran vdout0_10ck1870 FIND v(dout0_10) AT=1880.05n

.meas tran vdout0_11ck1870 FIND v(dout0_11) AT=1880.05n

.meas tran vdout0_12ck1870 FIND v(dout0_12) AT=1880.05n

.meas tran vdout0_13ck1870 FIND v(dout0_13) AT=1880.05n

.meas tran vdout0_14ck1870 FIND v(dout0_14) AT=1880.05n

.meas tran vdout0_15ck1870 FIND v(dout0_15) AT=1880.05n

.meas tran vdout0_16ck1870 FIND v(dout0_16) AT=1880.05n

.meas tran vdout0_17ck1870 FIND v(dout0_17) AT=1880.05n

.meas tran vdout0_18ck1870 FIND v(dout0_18) AT=1880.05n

.meas tran vdout0_19ck1870 FIND v(dout0_19) AT=1880.05n

.meas tran vdout0_20ck1870 FIND v(dout0_20) AT=1880.05n

.meas tran vdout0_21ck1870 FIND v(dout0_21) AT=1880.05n

.meas tran vdout0_22ck1870 FIND v(dout0_22) AT=1880.05n

.meas tran vdout0_23ck1870 FIND v(dout0_23) AT=1880.05n

.meas tran vdout0_24ck1870 FIND v(dout0_24) AT=1880.05n

.meas tran vdout0_25ck1870 FIND v(dout0_25) AT=1880.05n

.meas tran vdout0_26ck1870 FIND v(dout0_26) AT=1880.05n

.meas tran vdout0_27ck1870 FIND v(dout0_27) AT=1880.05n

.meas tran vdout0_28ck1870 FIND v(dout0_28) AT=1880.05n

.meas tran vdout0_29ck1870 FIND v(dout0_29) AT=1880.05n

.meas tran vdout0_30ck1870 FIND v(dout0_30) AT=1880.05n

.meas tran vdout0_31ck1870 FIND v(dout0_31) AT=1880.05n

.meas tran vdout0_0ck1900 FIND v(dout0_0) AT=1910.05n

.meas tran vdout0_1ck1900 FIND v(dout0_1) AT=1910.05n

.meas tran vdout0_2ck1900 FIND v(dout0_2) AT=1910.05n

.meas tran vdout0_3ck1900 FIND v(dout0_3) AT=1910.05n

.meas tran vdout0_4ck1900 FIND v(dout0_4) AT=1910.05n

.meas tran vdout0_5ck1900 FIND v(dout0_5) AT=1910.05n

.meas tran vdout0_6ck1900 FIND v(dout0_6) AT=1910.05n

.meas tran vdout0_7ck1900 FIND v(dout0_7) AT=1910.05n

.meas tran vdout0_8ck1900 FIND v(dout0_8) AT=1910.05n

.meas tran vdout0_9ck1900 FIND v(dout0_9) AT=1910.05n

.meas tran vdout0_10ck1900 FIND v(dout0_10) AT=1910.05n

.meas tran vdout0_11ck1900 FIND v(dout0_11) AT=1910.05n

.meas tran vdout0_12ck1900 FIND v(dout0_12) AT=1910.05n

.meas tran vdout0_13ck1900 FIND v(dout0_13) AT=1910.05n

.meas tran vdout0_14ck1900 FIND v(dout0_14) AT=1910.05n

.meas tran vdout0_15ck1900 FIND v(dout0_15) AT=1910.05n

.meas tran vdout0_16ck1900 FIND v(dout0_16) AT=1910.05n

.meas tran vdout0_17ck1900 FIND v(dout0_17) AT=1910.05n

.meas tran vdout0_18ck1900 FIND v(dout0_18) AT=1910.05n

.meas tran vdout0_19ck1900 FIND v(dout0_19) AT=1910.05n

.meas tran vdout0_20ck1900 FIND v(dout0_20) AT=1910.05n

.meas tran vdout0_21ck1900 FIND v(dout0_21) AT=1910.05n

.meas tran vdout0_22ck1900 FIND v(dout0_22) AT=1910.05n

.meas tran vdout0_23ck1900 FIND v(dout0_23) AT=1910.05n

.meas tran vdout0_24ck1900 FIND v(dout0_24) AT=1910.05n

.meas tran vdout0_25ck1900 FIND v(dout0_25) AT=1910.05n

.meas tran vdout0_26ck1900 FIND v(dout0_26) AT=1910.05n

.meas tran vdout0_27ck1900 FIND v(dout0_27) AT=1910.05n

.meas tran vdout0_28ck1900 FIND v(dout0_28) AT=1910.05n

.meas tran vdout0_29ck1900 FIND v(dout0_29) AT=1910.05n

.meas tran vdout0_30ck1900 FIND v(dout0_30) AT=1910.05n

.meas tran vdout0_31ck1900 FIND v(dout0_31) AT=1910.05n

.meas tran vdout0_0ck1940 FIND v(dout0_0) AT=1950.05n

.meas tran vdout0_1ck1940 FIND v(dout0_1) AT=1950.05n

.meas tran vdout0_2ck1940 FIND v(dout0_2) AT=1950.05n

.meas tran vdout0_3ck1940 FIND v(dout0_3) AT=1950.05n

.meas tran vdout0_4ck1940 FIND v(dout0_4) AT=1950.05n

.meas tran vdout0_5ck1940 FIND v(dout0_5) AT=1950.05n

.meas tran vdout0_6ck1940 FIND v(dout0_6) AT=1950.05n

.meas tran vdout0_7ck1940 FIND v(dout0_7) AT=1950.05n

.meas tran vdout0_8ck1940 FIND v(dout0_8) AT=1950.05n

.meas tran vdout0_9ck1940 FIND v(dout0_9) AT=1950.05n

.meas tran vdout0_10ck1940 FIND v(dout0_10) AT=1950.05n

.meas tran vdout0_11ck1940 FIND v(dout0_11) AT=1950.05n

.meas tran vdout0_12ck1940 FIND v(dout0_12) AT=1950.05n

.meas tran vdout0_13ck1940 FIND v(dout0_13) AT=1950.05n

.meas tran vdout0_14ck1940 FIND v(dout0_14) AT=1950.05n

.meas tran vdout0_15ck1940 FIND v(dout0_15) AT=1950.05n

.meas tran vdout0_16ck1940 FIND v(dout0_16) AT=1950.05n

.meas tran vdout0_17ck1940 FIND v(dout0_17) AT=1950.05n

.meas tran vdout0_18ck1940 FIND v(dout0_18) AT=1950.05n

.meas tran vdout0_19ck1940 FIND v(dout0_19) AT=1950.05n

.meas tran vdout0_20ck1940 FIND v(dout0_20) AT=1950.05n

.meas tran vdout0_21ck1940 FIND v(dout0_21) AT=1950.05n

.meas tran vdout0_22ck1940 FIND v(dout0_22) AT=1950.05n

.meas tran vdout0_23ck1940 FIND v(dout0_23) AT=1950.05n

.meas tran vdout0_24ck1940 FIND v(dout0_24) AT=1950.05n

.meas tran vdout0_25ck1940 FIND v(dout0_25) AT=1950.05n

.meas tran vdout0_26ck1940 FIND v(dout0_26) AT=1950.05n

.meas tran vdout0_27ck1940 FIND v(dout0_27) AT=1950.05n

.meas tran vdout0_28ck1940 FIND v(dout0_28) AT=1950.05n

.meas tran vdout0_29ck1940 FIND v(dout0_29) AT=1950.05n

.meas tran vdout0_30ck1940 FIND v(dout0_30) AT=1950.05n

.meas tran vdout0_31ck1940 FIND v(dout0_31) AT=1950.05n

.meas tran vdout0_0ck1950 FIND v(dout0_0) AT=1960.05n

.meas tran vdout0_1ck1950 FIND v(dout0_1) AT=1960.05n

.meas tran vdout0_2ck1950 FIND v(dout0_2) AT=1960.05n

.meas tran vdout0_3ck1950 FIND v(dout0_3) AT=1960.05n

.meas tran vdout0_4ck1950 FIND v(dout0_4) AT=1960.05n

.meas tran vdout0_5ck1950 FIND v(dout0_5) AT=1960.05n

.meas tran vdout0_6ck1950 FIND v(dout0_6) AT=1960.05n

.meas tran vdout0_7ck1950 FIND v(dout0_7) AT=1960.05n

.meas tran vdout0_8ck1950 FIND v(dout0_8) AT=1960.05n

.meas tran vdout0_9ck1950 FIND v(dout0_9) AT=1960.05n

.meas tran vdout0_10ck1950 FIND v(dout0_10) AT=1960.05n

.meas tran vdout0_11ck1950 FIND v(dout0_11) AT=1960.05n

.meas tran vdout0_12ck1950 FIND v(dout0_12) AT=1960.05n

.meas tran vdout0_13ck1950 FIND v(dout0_13) AT=1960.05n

.meas tran vdout0_14ck1950 FIND v(dout0_14) AT=1960.05n

.meas tran vdout0_15ck1950 FIND v(dout0_15) AT=1960.05n

.meas tran vdout0_16ck1950 FIND v(dout0_16) AT=1960.05n

.meas tran vdout0_17ck1950 FIND v(dout0_17) AT=1960.05n

.meas tran vdout0_18ck1950 FIND v(dout0_18) AT=1960.05n

.meas tran vdout0_19ck1950 FIND v(dout0_19) AT=1960.05n

.meas tran vdout0_20ck1950 FIND v(dout0_20) AT=1960.05n

.meas tran vdout0_21ck1950 FIND v(dout0_21) AT=1960.05n

.meas tran vdout0_22ck1950 FIND v(dout0_22) AT=1960.05n

.meas tran vdout0_23ck1950 FIND v(dout0_23) AT=1960.05n

.meas tran vdout0_24ck1950 FIND v(dout0_24) AT=1960.05n

.meas tran vdout0_25ck1950 FIND v(dout0_25) AT=1960.05n

.meas tran vdout0_26ck1950 FIND v(dout0_26) AT=1960.05n

.meas tran vdout0_27ck1950 FIND v(dout0_27) AT=1960.05n

.meas tran vdout0_28ck1950 FIND v(dout0_28) AT=1960.05n

.meas tran vdout0_29ck1950 FIND v(dout0_29) AT=1960.05n

.meas tran vdout0_30ck1950 FIND v(dout0_30) AT=1960.05n

.meas tran vdout0_31ck1950 FIND v(dout0_31) AT=1960.05n

.meas tran vdout0_0ck1960 FIND v(dout0_0) AT=1970.05n

.meas tran vdout0_1ck1960 FIND v(dout0_1) AT=1970.05n

.meas tran vdout0_2ck1960 FIND v(dout0_2) AT=1970.05n

.meas tran vdout0_3ck1960 FIND v(dout0_3) AT=1970.05n

.meas tran vdout0_4ck1960 FIND v(dout0_4) AT=1970.05n

.meas tran vdout0_5ck1960 FIND v(dout0_5) AT=1970.05n

.meas tran vdout0_6ck1960 FIND v(dout0_6) AT=1970.05n

.meas tran vdout0_7ck1960 FIND v(dout0_7) AT=1970.05n

.meas tran vdout0_8ck1960 FIND v(dout0_8) AT=1970.05n

.meas tran vdout0_9ck1960 FIND v(dout0_9) AT=1970.05n

.meas tran vdout0_10ck1960 FIND v(dout0_10) AT=1970.05n

.meas tran vdout0_11ck1960 FIND v(dout0_11) AT=1970.05n

.meas tran vdout0_12ck1960 FIND v(dout0_12) AT=1970.05n

.meas tran vdout0_13ck1960 FIND v(dout0_13) AT=1970.05n

.meas tran vdout0_14ck1960 FIND v(dout0_14) AT=1970.05n

.meas tran vdout0_15ck1960 FIND v(dout0_15) AT=1970.05n

.meas tran vdout0_16ck1960 FIND v(dout0_16) AT=1970.05n

.meas tran vdout0_17ck1960 FIND v(dout0_17) AT=1970.05n

.meas tran vdout0_18ck1960 FIND v(dout0_18) AT=1970.05n

.meas tran vdout0_19ck1960 FIND v(dout0_19) AT=1970.05n

.meas tran vdout0_20ck1960 FIND v(dout0_20) AT=1970.05n

.meas tran vdout0_21ck1960 FIND v(dout0_21) AT=1970.05n

.meas tran vdout0_22ck1960 FIND v(dout0_22) AT=1970.05n

.meas tran vdout0_23ck1960 FIND v(dout0_23) AT=1970.05n

.meas tran vdout0_24ck1960 FIND v(dout0_24) AT=1970.05n

.meas tran vdout0_25ck1960 FIND v(dout0_25) AT=1970.05n

.meas tran vdout0_26ck1960 FIND v(dout0_26) AT=1970.05n

.meas tran vdout0_27ck1960 FIND v(dout0_27) AT=1970.05n

.meas tran vdout0_28ck1960 FIND v(dout0_28) AT=1970.05n

.meas tran vdout0_29ck1960 FIND v(dout0_29) AT=1970.05n

.meas tran vdout0_30ck1960 FIND v(dout0_30) AT=1970.05n

.meas tran vdout0_31ck1960 FIND v(dout0_31) AT=1970.05n

.meas tran vdout0_0ck1990 FIND v(dout0_0) AT=2000.05n

.meas tran vdout0_1ck1990 FIND v(dout0_1) AT=2000.05n

.meas tran vdout0_2ck1990 FIND v(dout0_2) AT=2000.05n

.meas tran vdout0_3ck1990 FIND v(dout0_3) AT=2000.05n

.meas tran vdout0_4ck1990 FIND v(dout0_4) AT=2000.05n

.meas tran vdout0_5ck1990 FIND v(dout0_5) AT=2000.05n

.meas tran vdout0_6ck1990 FIND v(dout0_6) AT=2000.05n

.meas tran vdout0_7ck1990 FIND v(dout0_7) AT=2000.05n

.meas tran vdout0_8ck1990 FIND v(dout0_8) AT=2000.05n

.meas tran vdout0_9ck1990 FIND v(dout0_9) AT=2000.05n

.meas tran vdout0_10ck1990 FIND v(dout0_10) AT=2000.05n

.meas tran vdout0_11ck1990 FIND v(dout0_11) AT=2000.05n

.meas tran vdout0_12ck1990 FIND v(dout0_12) AT=2000.05n

.meas tran vdout0_13ck1990 FIND v(dout0_13) AT=2000.05n

.meas tran vdout0_14ck1990 FIND v(dout0_14) AT=2000.05n

.meas tran vdout0_15ck1990 FIND v(dout0_15) AT=2000.05n

.meas tran vdout0_16ck1990 FIND v(dout0_16) AT=2000.05n

.meas tran vdout0_17ck1990 FIND v(dout0_17) AT=2000.05n

.meas tran vdout0_18ck1990 FIND v(dout0_18) AT=2000.05n

.meas tran vdout0_19ck1990 FIND v(dout0_19) AT=2000.05n

.meas tran vdout0_20ck1990 FIND v(dout0_20) AT=2000.05n

.meas tran vdout0_21ck1990 FIND v(dout0_21) AT=2000.05n

.meas tran vdout0_22ck1990 FIND v(dout0_22) AT=2000.05n

.meas tran vdout0_23ck1990 FIND v(dout0_23) AT=2000.05n

.meas tran vdout0_24ck1990 FIND v(dout0_24) AT=2000.05n

.meas tran vdout0_25ck1990 FIND v(dout0_25) AT=2000.05n

.meas tran vdout0_26ck1990 FIND v(dout0_26) AT=2000.05n

.meas tran vdout0_27ck1990 FIND v(dout0_27) AT=2000.05n

.meas tran vdout0_28ck1990 FIND v(dout0_28) AT=2000.05n

.meas tran vdout0_29ck1990 FIND v(dout0_29) AT=2000.05n

.meas tran vdout0_30ck1990 FIND v(dout0_30) AT=2000.05n

.meas tran vdout0_31ck1990 FIND v(dout0_31) AT=2000.05n

.meas tran vdout0_0ck2000 FIND v(dout0_0) AT=2010.05n

.meas tran vdout0_1ck2000 FIND v(dout0_1) AT=2010.05n

.meas tran vdout0_2ck2000 FIND v(dout0_2) AT=2010.05n

.meas tran vdout0_3ck2000 FIND v(dout0_3) AT=2010.05n

.meas tran vdout0_4ck2000 FIND v(dout0_4) AT=2010.05n

.meas tran vdout0_5ck2000 FIND v(dout0_5) AT=2010.05n

.meas tran vdout0_6ck2000 FIND v(dout0_6) AT=2010.05n

.meas tran vdout0_7ck2000 FIND v(dout0_7) AT=2010.05n

.meas tran vdout0_8ck2000 FIND v(dout0_8) AT=2010.05n

.meas tran vdout0_9ck2000 FIND v(dout0_9) AT=2010.05n

.meas tran vdout0_10ck2000 FIND v(dout0_10) AT=2010.05n

.meas tran vdout0_11ck2000 FIND v(dout0_11) AT=2010.05n

.meas tran vdout0_12ck2000 FIND v(dout0_12) AT=2010.05n

.meas tran vdout0_13ck2000 FIND v(dout0_13) AT=2010.05n

.meas tran vdout0_14ck2000 FIND v(dout0_14) AT=2010.05n

.meas tran vdout0_15ck2000 FIND v(dout0_15) AT=2010.05n

.meas tran vdout0_16ck2000 FIND v(dout0_16) AT=2010.05n

.meas tran vdout0_17ck2000 FIND v(dout0_17) AT=2010.05n

.meas tran vdout0_18ck2000 FIND v(dout0_18) AT=2010.05n

.meas tran vdout0_19ck2000 FIND v(dout0_19) AT=2010.05n

.meas tran vdout0_20ck2000 FIND v(dout0_20) AT=2010.05n

.meas tran vdout0_21ck2000 FIND v(dout0_21) AT=2010.05n

.meas tran vdout0_22ck2000 FIND v(dout0_22) AT=2010.05n

.meas tran vdout0_23ck2000 FIND v(dout0_23) AT=2010.05n

.meas tran vdout0_24ck2000 FIND v(dout0_24) AT=2010.05n

.meas tran vdout0_25ck2000 FIND v(dout0_25) AT=2010.05n

.meas tran vdout0_26ck2000 FIND v(dout0_26) AT=2010.05n

.meas tran vdout0_27ck2000 FIND v(dout0_27) AT=2010.05n

.meas tran vdout0_28ck2000 FIND v(dout0_28) AT=2010.05n

.meas tran vdout0_29ck2000 FIND v(dout0_29) AT=2010.05n

.meas tran vdout0_30ck2000 FIND v(dout0_30) AT=2010.05n

.meas tran vdout0_31ck2000 FIND v(dout0_31) AT=2010.05n

.meas tran vdout0_0ck2010 FIND v(dout0_0) AT=2020.05n

.meas tran vdout0_1ck2010 FIND v(dout0_1) AT=2020.05n

.meas tran vdout0_2ck2010 FIND v(dout0_2) AT=2020.05n

.meas tran vdout0_3ck2010 FIND v(dout0_3) AT=2020.05n

.meas tran vdout0_4ck2010 FIND v(dout0_4) AT=2020.05n

.meas tran vdout0_5ck2010 FIND v(dout0_5) AT=2020.05n

.meas tran vdout0_6ck2010 FIND v(dout0_6) AT=2020.05n

.meas tran vdout0_7ck2010 FIND v(dout0_7) AT=2020.05n

.meas tran vdout0_8ck2010 FIND v(dout0_8) AT=2020.05n

.meas tran vdout0_9ck2010 FIND v(dout0_9) AT=2020.05n

.meas tran vdout0_10ck2010 FIND v(dout0_10) AT=2020.05n

.meas tran vdout0_11ck2010 FIND v(dout0_11) AT=2020.05n

.meas tran vdout0_12ck2010 FIND v(dout0_12) AT=2020.05n

.meas tran vdout0_13ck2010 FIND v(dout0_13) AT=2020.05n

.meas tran vdout0_14ck2010 FIND v(dout0_14) AT=2020.05n

.meas tran vdout0_15ck2010 FIND v(dout0_15) AT=2020.05n

.meas tran vdout0_16ck2010 FIND v(dout0_16) AT=2020.05n

.meas tran vdout0_17ck2010 FIND v(dout0_17) AT=2020.05n

.meas tran vdout0_18ck2010 FIND v(dout0_18) AT=2020.05n

.meas tran vdout0_19ck2010 FIND v(dout0_19) AT=2020.05n

.meas tran vdout0_20ck2010 FIND v(dout0_20) AT=2020.05n

.meas tran vdout0_21ck2010 FIND v(dout0_21) AT=2020.05n

.meas tran vdout0_22ck2010 FIND v(dout0_22) AT=2020.05n

.meas tran vdout0_23ck2010 FIND v(dout0_23) AT=2020.05n

.meas tran vdout0_24ck2010 FIND v(dout0_24) AT=2020.05n

.meas tran vdout0_25ck2010 FIND v(dout0_25) AT=2020.05n

.meas tran vdout0_26ck2010 FIND v(dout0_26) AT=2020.05n

.meas tran vdout0_27ck2010 FIND v(dout0_27) AT=2020.05n

.meas tran vdout0_28ck2010 FIND v(dout0_28) AT=2020.05n

.meas tran vdout0_29ck2010 FIND v(dout0_29) AT=2020.05n

.meas tran vdout0_30ck2010 FIND v(dout0_30) AT=2020.05n

.meas tran vdout0_31ck2010 FIND v(dout0_31) AT=2020.05n

.meas tran vdout0_0ck2040 FIND v(dout0_0) AT=2050.05n

.meas tran vdout0_1ck2040 FIND v(dout0_1) AT=2050.05n

.meas tran vdout0_2ck2040 FIND v(dout0_2) AT=2050.05n

.meas tran vdout0_3ck2040 FIND v(dout0_3) AT=2050.05n

.meas tran vdout0_4ck2040 FIND v(dout0_4) AT=2050.05n

.meas tran vdout0_5ck2040 FIND v(dout0_5) AT=2050.05n

.meas tran vdout0_6ck2040 FIND v(dout0_6) AT=2050.05n

.meas tran vdout0_7ck2040 FIND v(dout0_7) AT=2050.05n

.meas tran vdout0_8ck2040 FIND v(dout0_8) AT=2050.05n

.meas tran vdout0_9ck2040 FIND v(dout0_9) AT=2050.05n

.meas tran vdout0_10ck2040 FIND v(dout0_10) AT=2050.05n

.meas tran vdout0_11ck2040 FIND v(dout0_11) AT=2050.05n

.meas tran vdout0_12ck2040 FIND v(dout0_12) AT=2050.05n

.meas tran vdout0_13ck2040 FIND v(dout0_13) AT=2050.05n

.meas tran vdout0_14ck2040 FIND v(dout0_14) AT=2050.05n

.meas tran vdout0_15ck2040 FIND v(dout0_15) AT=2050.05n

.meas tran vdout0_16ck2040 FIND v(dout0_16) AT=2050.05n

.meas tran vdout0_17ck2040 FIND v(dout0_17) AT=2050.05n

.meas tran vdout0_18ck2040 FIND v(dout0_18) AT=2050.05n

.meas tran vdout0_19ck2040 FIND v(dout0_19) AT=2050.05n

.meas tran vdout0_20ck2040 FIND v(dout0_20) AT=2050.05n

.meas tran vdout0_21ck2040 FIND v(dout0_21) AT=2050.05n

.meas tran vdout0_22ck2040 FIND v(dout0_22) AT=2050.05n

.meas tran vdout0_23ck2040 FIND v(dout0_23) AT=2050.05n

.meas tran vdout0_24ck2040 FIND v(dout0_24) AT=2050.05n

.meas tran vdout0_25ck2040 FIND v(dout0_25) AT=2050.05n

.meas tran vdout0_26ck2040 FIND v(dout0_26) AT=2050.05n

.meas tran vdout0_27ck2040 FIND v(dout0_27) AT=2050.05n

.meas tran vdout0_28ck2040 FIND v(dout0_28) AT=2050.05n

.meas tran vdout0_29ck2040 FIND v(dout0_29) AT=2050.05n

.meas tran vdout0_30ck2040 FIND v(dout0_30) AT=2050.05n

.meas tran vdout0_31ck2040 FIND v(dout0_31) AT=2050.05n
